* Testcase 000609 — Full Analysis (sky130 tt corner)
* SKY130 model header — replaces the ideal level-1 .model cards
* Ships with the demo; the paths point at the local sky130 PDK checkout.
* NOTE: libs.tech/ngspice/all.spice sets ".option scale=1.0u", so every
* instance L/W below is written in microns WITHOUT a "u" suffix.
.param mc_mm_switch=0
.param mc_pr_switch=0
.include /home/idies/workspace/Temporary/xyu1/scratch/skywater-pdk-libs-sky130_fd_pr/models/corners/tt.spice
.include /home/idies/workspace/Temporary/xyu1/scratch/skywater-pdk-libs-sky130_fd_pr/models/r+c/res_typical__cap_typical.spice
.include /home/idies/workspace/Temporary/xyu1/scratch/skywater-pdk-libs-sky130_fd_pr/models/r+c/res_typical__cap_typical__lin.spice
.include /home/idies/workspace/Temporary/xyu1/scratch/skywater-pdk-libs-sky130_fd_pr/models/corners/tt/specialized_cells.spice
.model DIDEAL D   is=1e-14 n=1
.options reltol=1e-3 itl1=500 itl2=100

* Sources

* Circuit
R1 VCC N_C2 10k
R2 VCC N_C1 10k
R3 OUTPUT_P VEE 10k
R4 N_E6 VEE 10k
R5 OUTPUT_N VEE 10k
XQ1 N_C1 RETIMED_DATA_N N_E34 0 sky130_fd_pr__npn_05v5_W1p00L1p00
XQ2 N_E12 DELAYED_DATA_P N_E5 0 sky130_fd_pr__npn_05v5_W1p00L1p00
XQ3 N_C1 RETIMED_DATA_P N_E12 0 sky130_fd_pr__npn_05v5_W1p00L1p00
XQ4 VCC N_C2 OUTPUT_N 0 sky130_fd_pr__npn_05v5_W1p00L1p00
XQ5 N_E5 VCS N_E6 0 sky130_fd_pr__npn_05v5_W1p00L1p00
XQ6 N_C2 RETIMED_DATA_N N_E12 0 sky130_fd_pr__npn_05v5_W1p00L1p00
XQ7 VCC N_C1 OUTPUT_P 0 sky130_fd_pr__npn_05v5_W1p00L1p00
XQ8 N_E34 DELAYED_DATA_N N_E5 0 sky130_fd_pr__npn_05v5_W1p00L1p00
XQ9 N_C2 RETIMED_DATA_P N_E34 0 sky130_fd_pr__npn_05v5_W1p00L1p00

.control
set filetype=ascii

op
let vdd_current = abs(i(VVDD))
let power_dc = vdd_current * 1.8
print power_dc

print all

quit
.endc

.end
