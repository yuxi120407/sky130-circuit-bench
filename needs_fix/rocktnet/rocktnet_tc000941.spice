* Testcase 000941 — Full Analysis (sky130 tt corner)
* SKY130 model header — replaces the ideal level-1 .model cards
* Ships with the demo; the paths point at the local sky130 PDK checkout.
* NOTE: libs.tech/ngspice/all.spice sets ".option scale=1.0u", so every
* instance L/W below is written in microns WITHOUT a "u" suffix.
.param mc_mm_switch=0
.param mc_pr_switch=0
.include /home/idies/workspace/Temporary/xyu1/scratch/skywater-pdk-libs-sky130_fd_pr/models/corners/tt.spice
.include /home/idies/workspace/Temporary/xyu1/scratch/skywater-pdk-libs-sky130_fd_pr/models/r+c/res_typical__cap_typical.spice
.include /home/idies/workspace/Temporary/xyu1/scratch/skywater-pdk-libs-sky130_fd_pr/models/r+c/res_typical__cap_typical__lin.spice
.include /home/idies/workspace/Temporary/xyu1/scratch/skywater-pdk-libs-sky130_fd_pr/models/corners/tt/specialized_cells.spice
.model DIDEAL D   is=1e-14 n=1
.options reltol=1e-3 itl1=500 itl2=100

* Sources
VVDD VDD 0 1.8
VVIN_N VIN_N 0 DC 0.9 AC 1 SIN(0.9 0.1 1MEG 0 0)
VVIN_P VIN_P 0 DC 0.9 AC 1 SIN(0.9 0.1 1MEG 0 0)
VLABEL_NET_0 LABEL_NET_0 0 0.9
VVINT_P VINT_P 0 DC 0.9 AC 1 SIN(0.9 0.1 1MEG 0 0)
VVINT_N VINT_N 0 DC 0.9 AC 1 SIN(0.9 0.1 1MEG 0 0)

* Circuit
I2I VDD VIN_N 1u
I10I VDD VIN_P 1u
XQR GND GND VIN_N sky130_fd_pr__pnp_05v5_W3p40L3p40
XQL GND GND VIN_P sky130_fd_pr__pnp_05v5_W3p40L3p40
C1 VIN_P N4 1p
C2 N3 VIN_N 1p
C3 N4 LABEL_NET_0 1p
C4 VINT_P N4 1p
C5 VINT_N N3 1p
C6 N3 VIN_N 1p

.control
set filetype=ascii

op
let vdd_current = abs(i(VVDD))
let power_dc = vdd_current * 1.8
print power_dc

print all

quit
.endc

.end
