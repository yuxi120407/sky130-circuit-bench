* Testcase 000714 — Full Analysis (sky130 tt corner)
* SKY130 model header — replaces the ideal level-1 .model cards
* Ships with the demo; the paths point at the local sky130 PDK checkout.
* NOTE: libs.tech/ngspice/all.spice sets ".option scale=1.0u", so every
* instance L/W below is written in microns WITHOUT a "u" suffix.
.param mc_mm_switch=0
.param mc_pr_switch=0
.include /home/idies/workspace/Temporary/xyu1/scratch/skywater-pdk-libs-sky130_fd_pr/models/corners/tt.spice
.include /home/idies/workspace/Temporary/xyu1/scratch/skywater-pdk-libs-sky130_fd_pr/models/r+c/res_typical__cap_typical.spice
.include /home/idies/workspace/Temporary/xyu1/scratch/skywater-pdk-libs-sky130_fd_pr/models/r+c/res_typical__cap_typical__lin.spice
.include /home/idies/workspace/Temporary/xyu1/scratch/skywater-pdk-libs-sky130_fd_pr/models/corners/tt/specialized_cells.spice
.model DIDEAL D   is=1e-14 n=1
.options reltol=1e-3 itl1=500 itl2=100

* Sources
VVDD VDD 0 1.8

* Circuit
XQ1 N4 N5 N3 0 sky130_fd_pr__npn_05v5_W1p00L1p00
XQ2 N12 N14 N3 0 sky130_fd_pr__npn_05v5_W1p00L1p00
R1 Q_P N6 10k
XQ3 N14 N14 N9 0 sky130_fd_pr__npn_05v5_W1p00L1p00
XQ4 VDD N1 Q_N 0 sky130_fd_pr__npn_05v5_W1p00L1p00
XQ5 VDD CLK_N N14 0 sky130_fd_pr__npn_05v5_W1p00L1p00
XQ6 N6 N6 GND 0 sky130_fd_pr__npn_05v5_W1p00L1p00
XQ7 N1 D_P N4 0 sky130_fd_pr__npn_05v5_W1p00L1p00
XQ8 N1 Q_P N12 0 sky130_fd_pr__npn_05v5_W1p00L1p00
R2 Q_N N6 10k
R3 N7 VDD 10k
R4 N1 VDD 10k
XQ9 N9 N6 GND 0 sky130_fd_pr__npn_05v5_W1p00L1p00
XQ10 N7 D_N N4 0 sky130_fd_pr__npn_05v5_W1p00L1p00
XQ11 N7 Q_N N12 0 sky130_fd_pr__npn_05v5_W1p00L1p00
XQ12 N5 N5 N13 0 sky130_fd_pr__npn_05v5_W1p00L1p00
XQ13 VDD CLK_P N5 0 sky130_fd_pr__npn_05v5_W1p00L1p00
XQ14 N3 N6 GND 0 sky130_fd_pr__npn_05v5_W1p00L1p00
XQ15 N13 N6 GND 0 sky130_fd_pr__npn_05v5_W1p00L1p00
XQ16 VDD N7 Q_P 0 sky130_fd_pr__npn_05v5_W1p00L1p00

.control
set filetype=ascii

op
let vdd_current = abs(i(VVDD))
let power_dc = vdd_current * 1.8
print power_dc

print all

quit
.endc

.end
