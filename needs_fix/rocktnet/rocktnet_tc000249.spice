* Testcase 000249 — Full Analysis (sky130 tt corner)
* SKY130 model header — replaces the ideal level-1 .model cards
* Ships with the demo; the paths point at the local sky130 PDK checkout.
* NOTE: libs.tech/ngspice/all.spice sets ".option scale=1.0u", so every
* instance L/W below is written in microns WITHOUT a "u" suffix.
.param mc_mm_switch=0
.param mc_pr_switch=0
.include /home/idies/workspace/Temporary/xyu1/scratch/skywater-pdk-libs-sky130_fd_pr/models/corners/tt.spice
.include /home/idies/workspace/Temporary/xyu1/scratch/skywater-pdk-libs-sky130_fd_pr/models/r+c/res_typical__cap_typical.spice
.include /home/idies/workspace/Temporary/xyu1/scratch/skywater-pdk-libs-sky130_fd_pr/models/r+c/res_typical__cap_typical__lin.spice
.include /home/idies/workspace/Temporary/xyu1/scratch/skywater-pdk-libs-sky130_fd_pr/models/corners/tt/specialized_cells.spice
.model DIDEAL D   is=1e-14 n=1
.options reltol=1e-3 itl1=500 itl2=100

* Sources
VIN1 IN1 0 DC 0.9 AC 1 SIN(0.9 0.1 1MEG 0 0)
VIN2 IN2 0 DC 0.9 AC 1 SIN(0.9 0.1 1MEG 0 0)
VVBIAS VBIAS 0 0.75

* Circuit
LS GND N1 10n
LS GND N2 10n
R3 N1 OUT1 50
R5 N2 OUT2 50
XQ4 GND IN1 N3 0 sky130_fd_pr__npn_05v5_W1p00L1p00
XQ1 GND IN2 N4 0 sky130_fd_pr__npn_05v5_W1p00L1p00
XQ6 N3 VBIAS N5 0 sky130_fd_pr__npn_05v5_W1p00L1p00
XQ5 N4 VBIAS N6 0 sky130_fd_pr__npn_05v5_W1p00L1p00
R4 N5 n3.6V 10k
R1 N6 n3.6V 10k
XQ2 OUT1 N3 N7 0 sky130_fd_pr__npn_05v5_W1p00L1p00
XQ7 OUT2 N4 N8 0 sky130_fd_pr__npn_05v5_W1p00L1p00
CS N7 N8 1p
RS N7 N9 10k
RS N8 N9 10k
XQ3 N9 VBIAS N10 0 sky130_fd_pr__npn_05v5_W1p00L1p00
R2 N10 n3.6V 10k

.control
set filetype=ascii

op
let vdd_current = abs(i(VVDD))
let power_dc = vdd_current * 1.8
print power_dc

print all

quit
.endc

.end
