* Testcase 000639 — Full Analysis (sky130 tt corner)
* SKY130 model header — replaces the ideal level-1 .model cards
* Ships with the demo; the paths point at the local sky130 PDK checkout.
* NOTE: libs.tech/ngspice/all.spice sets ".option scale=1.0u", so every
* instance L/W below is written in microns WITHOUT a "u" suffix.
.param mc_mm_switch=0
.param mc_pr_switch=0
.include /home/idies/workspace/Temporary/xyu1/scratch/skywater-pdk-libs-sky130_fd_pr/models/corners/tt.spice
.include /home/idies/workspace/Temporary/xyu1/scratch/skywater-pdk-libs-sky130_fd_pr/models/r+c/res_typical__cap_typical.spice
.include /home/idies/workspace/Temporary/xyu1/scratch/skywater-pdk-libs-sky130_fd_pr/models/r+c/res_typical__cap_typical__lin.spice
.include /home/idies/workspace/Temporary/xyu1/scratch/skywater-pdk-libs-sky130_fd_pr/models/corners/tt/specialized_cells.spice
.model DIDEAL D   is=1e-14 n=1
.options reltol=1e-2 abstol=1e-10 vntol=1e-4 itl1=1000 itl2=200 itl4=100
.options gmin=1e-10 method=gear

* Sources

* Circuit
XQ1 N0 DINP N4 0 sky130_fd_pr__npn_05v5_W1p00L1p00
C1 N2 N3 1.1p
R1 N11 GND 10k
XQ2 N9 N3 N14 0 sky130_fd_pr__npn_05v5_W1p00L1p00
XQ3 N13 N2 N14 0 sky130_fd_pr__npn_05v5_W1p00L1p00
R2 N5 N13 10k
XQ4 N1 DINN N4 0 sky130_fd_pr__npn_05v5_W1p00L1p00
R3 N5 N9 10k
XQ5 N14 N10 N18 0 sky130_fd_pr__npn_05v5_W1p00L1p00
R4 N7 N12 10k
R5 N5 N8 10k
R6 N18 GND 10k
R8 N15 GND 10k
R7 N7 N8 10k
C2 N13 N16 1.1p
R9 N6 N7 10k
R10 N1 N12 10k
C3 N9 N19 1.1p
XQ6 N10 IFDB N11 0 sky130_fd_pr__npn_05v5_W1p00L1p00
R11 N1 N0 10k
R12 N3 N2 10k
R15 N2 N3 10k
R14 N0 N6 10k
R13 N2 N16 10k
XQ7 N4 N10 N15 0 sky130_fd_pr__npn_05v5_W1p00L1p00
R16 N0 N1 10k
R17 N3 N19 10k

.control
set filetype=ascii

op

let dc_voltage = v(N0)
print dc_voltage
print all

quit
.endc

.end
