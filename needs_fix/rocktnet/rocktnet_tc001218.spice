* Testcase 001218 — Full Analysis (sky130 tt corner)
* SKY130 model header — replaces the ideal level-1 .model cards
* Ships with the demo; the paths point at the local sky130 PDK checkout.
* NOTE: libs.tech/ngspice/all.spice sets ".option scale=1.0u", so every
* instance L/W below is written in microns WITHOUT a "u" suffix.
.param mc_mm_switch=0
.param mc_pr_switch=0
.include /home/idies/workspace/Temporary/xyu1/scratch/skywater-pdk-libs-sky130_fd_pr/models/corners/tt.spice
.include /home/idies/workspace/Temporary/xyu1/scratch/skywater-pdk-libs-sky130_fd_pr/models/r+c/res_typical__cap_typical.spice
.include /home/idies/workspace/Temporary/xyu1/scratch/skywater-pdk-libs-sky130_fd_pr/models/r+c/res_typical__cap_typical__lin.spice
.include /home/idies/workspace/Temporary/xyu1/scratch/skywater-pdk-libs-sky130_fd_pr/models/corners/tt/specialized_cells.spice
.model DIDEAL D   is=1e-14 n=1
.options reltol=1e-3 itl1=500 itl2=100

* Sources

* Circuit
IBIAS1 RB VEE 200u
IBIAS2 RBB VEE 200u
XQRB O Q4_BASE RB 0 sky130_fd_pr__npn_05v5_W1p00L1p00
XQRBB OB Q3_BASE RBB 0 sky130_fd_pr__npn_05v5_W1p00L1p00
XQDB Q3_BASE Q3_BASE RB 0 sky130_fd_pr__npn_05v5_W1p00L1p00
XQD Q4_BASE Q4_BASE RBB 0 sky130_fd_pr__npn_05v5_W1p00L1p00
RC2 VCC OB 800
RD2 VCC Q3_BASE 1.6k
RD1 VCC Q4_BASE 1.6k
RC1 VCC O 800

.control
set filetype=ascii

op
let vdd_current = abs(i(VVDD))
let power_dc = vdd_current * 1.8
print power_dc

print all

quit
.endc

.end
