* Testcase 000564 — Full Analysis (sky130 tt corner)
* SKY130 model header — replaces the ideal level-1 .model cards
* Ships with the demo; the paths point at the local sky130 PDK checkout.
* NOTE: libs.tech/ngspice/all.spice sets ".option scale=1.0u", so every
* instance L/W below is written in microns WITHOUT a "u" suffix.
.param mc_mm_switch=0
.param mc_pr_switch=0
.include /home/idies/workspace/Temporary/xyu1/scratch/skywater-pdk-libs-sky130_fd_pr/models/corners/tt.spice
.include /home/idies/workspace/Temporary/xyu1/scratch/skywater-pdk-libs-sky130_fd_pr/models/r+c/res_typical__cap_typical.spice
.include /home/idies/workspace/Temporary/xyu1/scratch/skywater-pdk-libs-sky130_fd_pr/models/r+c/res_typical__cap_typical__lin.spice
.include /home/idies/workspace/Temporary/xyu1/scratch/skywater-pdk-libs-sky130_fd_pr/models/corners/tt/specialized_cells.spice
.model DIDEAL D   is=1e-14 n=1
.options reltol=1e-2 abstol=1e-10 vntol=1e-4 itl1=1000 itl2=200 itl4=100
.options gmin=1e-10 method=gear

* Sources

* Circuit
XHBT3 N5 N10 N9 0 sky130_fd_pr__npn_05v5_W1p00L1p00
XHBT4 VREG N5 N1 0 sky130_fd_pr__npn_05v5_W1p00L1p00
XHBT1 N7 N1 GND 0 sky130_fd_pr__npn_05v5_W1p00L1p00
RFC N7 VCC 10k
XHBT2 N3 N4 GND 0 sky130_fd_pr__npn_05v5_W1p00L1p00
RB N1 N4 10k
R3 N3 N10 10k
R2 VREG N3 10k
R1 VREG N5 10k
R4 N9 GND 10k
C1 N2 RFOUT 1p
C2 N1 RFIN 1p
CB N5 GND 1p
C4 N2 GND 1p
CBYPASS N3 GND 1p
L1 RFIN GND 10n
R7 N2 N6 10k

.control
set filetype=ascii

op

let dc_voltage = v(N1)
print dc_voltage
print all

quit
.endc

.end
