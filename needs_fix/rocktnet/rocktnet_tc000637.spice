* Testcase 000637 — Full Analysis (sky130 tt corner)
* SKY130 model header — replaces the ideal level-1 .model cards
* Ships with the demo; the paths point at the local sky130 PDK checkout.
* NOTE: libs.tech/ngspice/all.spice sets ".option scale=1.0u", so every
* instance L/W below is written in microns WITHOUT a "u" suffix.
.param mc_mm_switch=0
.param mc_pr_switch=0
.include /home/idies/workspace/Temporary/xyu1/scratch/skywater-pdk-libs-sky130_fd_pr/models/corners/tt.spice
.include /home/idies/workspace/Temporary/xyu1/scratch/skywater-pdk-libs-sky130_fd_pr/models/r+c/res_typical__cap_typical.spice
.include /home/idies/workspace/Temporary/xyu1/scratch/skywater-pdk-libs-sky130_fd_pr/models/r+c/res_typical__cap_typical__lin.spice
.include /home/idies/workspace/Temporary/xyu1/scratch/skywater-pdk-libs-sky130_fd_pr/models/corners/tt/specialized_cells.spice
.model DIDEAL D   is=1e-14 n=1
.options reltol=1e-2 abstol=1e-10 vntol=1e-4 itl1=1000 itl2=200 itl4=100
.options gmin=1e-10 method=gear

* Sources

* Circuit
XQ1 OUTN DINP N3 0 sky130_fd_pr__npn_05v5_W1p00L1p00
XQ2 N10 N10 N18 0 sky130_fd_pr__npn_05v5_W1p00L1p00
XQ3 N3 N17 N11 0 sky130_fd_pr__npn_05v5_W1p00L1p00
XQ4 N3 N21 N13 0 sky130_fd_pr__npn_05v5_W1p00L1p00
R1 OUTN N6 10k
XQ5 N3 N15 N12 0 sky130_fd_pr__npn_05v5_W1p00L1p00
XQ6 N3 N20 N9 0 sky130_fd_pr__npn_05v5_W1p00L1p00
XQ7 N18 N14 N8 0 sky130_fd_pr__npn_05v5_W1p00L1p00
R2 OUTP N6 10k
XQ8 ITDRV TLDRV1_TLRX1 N7 0 sky130_fd_pr__npn_05v5_W1p00L1p00
XQ9 OUTP DINN N3 0 sky130_fd_pr__npn_05v5_W1p00L1p00
R3 N2 DINN 10k
C1 N2 GND 1p
R4 N1 3_3V 10k
R5 N7 GND 10k
XQ10 N3 ITDRV N19 0 sky130_fd_pr__npn_05v5_W1p00L1p00
C2 3_3V GND 1p
R6 N11 GND 10k
R7 N2 N2 10k
C3 N1 GND 1p
R8 N10 REFMON 10k
R9 3_3V N6 10k
R10 3_3V N10 10k
R11 N19 GND 10k
R12 N13 GND 10k
R13 N12 GND 10k
R14 N14 N16 10k
R15 N9 GND 10k
R16 N8 GND 10k
XQ11 N1 N2 N3 0 sky130_fd_pr__npn_05v5_W1p00L1p00
R17 N1 MON 10k

.control
set filetype=ascii

op

let dc_voltage = v(3_3V)
print dc_voltage
print all

quit
.endc

.end
