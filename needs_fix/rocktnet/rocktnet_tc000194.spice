* Testcase 000194 — Full Analysis (sky130 tt corner)
* SKY130 model header — replaces the ideal level-1 .model cards
* Ships with the demo; the paths point at the local sky130 PDK checkout.
* NOTE: libs.tech/ngspice/all.spice sets ".option scale=1.0u", so every
* instance L/W below is written in microns WITHOUT a "u" suffix.
.param mc_mm_switch=0
.param mc_pr_switch=0
.include /home/idies/workspace/Temporary/xyu1/scratch/skywater-pdk-libs-sky130_fd_pr/models/corners/tt.spice
.include /home/idies/workspace/Temporary/xyu1/scratch/skywater-pdk-libs-sky130_fd_pr/models/r+c/res_typical__cap_typical.spice
.include /home/idies/workspace/Temporary/xyu1/scratch/skywater-pdk-libs-sky130_fd_pr/models/r+c/res_typical__cap_typical__lin.spice
.include /home/idies/workspace/Temporary/xyu1/scratch/skywater-pdk-libs-sky130_fd_pr/models/corners/tt/specialized_cells.spice
.model DIDEAL D   is=1e-14 n=1
.options reltol=1e-3 itl1=500 itl2=100

* Sources
VVDD VDD 0 1.8
VVB VB 0 DC 0.75 AC 0.5

* Circuit
I1 A GND 1u
I2 C GND 1u
I3 D GND 1u
L1 VDD 0_DEG 10n
I4 B GND 1u
L2 VDD 270_DEG 10n
L3 VDD 90_DEG 10n
L4 VDD 180_DEG 10n
XM1 0_DEG 180_DEG A GND sky130_fd_pr__nfet_01v8 l=0.5 w=5
XM2 180_DEG 0_DEG A GND sky130_fd_pr__nfet_01v8 l=0.5 w=5
XM3 270_DEG 90_DEG B GND sky130_fd_pr__nfet_01v8 l=0.5 w=5
XM7 270_DEG 180_DEG D GND sky130_fd_pr__nfet_01v8 l=0.5 w=5
XM4 90_DEG 270_DEG B GND sky130_fd_pr__nfet_01v8 l=0.5 w=5
XM6 180_DEG 90_DEG C GND sky130_fd_pr__nfet_01v8 l=0.5 w=5
XM8 90_DEG 0_DEG D GND sky130_fd_pr__nfet_01v8 l=0.5 w=5
XM5 0_DEG 270_DEG C GND sky130_fd_pr__nfet_01v8 l=0.5 w=5
C1 90_DEG 90_DEG 1p
C2 VB 0_DEG 1p
C3 VB 180_DEG 1p
C4 270_DEG 270_DEG 1p

.control
set filetype=ascii

op
let vdd_current = abs(i(VVDD))
let power_dc = vdd_current * 1.8
print power_dc

print all

quit
.endc

.end
