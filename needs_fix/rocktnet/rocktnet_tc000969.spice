* Testcase 000969 — Full Analysis (sky130 tt corner)
* SKY130 model header — replaces the ideal level-1 .model cards
* Ships with the demo; the paths point at the local sky130 PDK checkout.
* NOTE: libs.tech/ngspice/all.spice sets ".option scale=1.0u", so every
* instance L/W below is written in microns WITHOUT a "u" suffix.
.param mc_mm_switch=0
.param mc_pr_switch=0
.include /home/idies/workspace/Temporary/xyu1/scratch/skywater-pdk-libs-sky130_fd_pr/models/corners/tt.spice
.include /home/idies/workspace/Temporary/xyu1/scratch/skywater-pdk-libs-sky130_fd_pr/models/r+c/res_typical__cap_typical.spice
.include /home/idies/workspace/Temporary/xyu1/scratch/skywater-pdk-libs-sky130_fd_pr/models/r+c/res_typical__cap_typical__lin.spice
.include /home/idies/workspace/Temporary/xyu1/scratch/skywater-pdk-libs-sky130_fd_pr/models/corners/tt/specialized_cells.spice
.model DIDEAL D   is=1e-14 n=1
.options reltol=1e-3 itl1=500 itl2=100

* Sources
VVDD VDD 0 1.8
VVB0 VB0 0 DC 0.9900000000000001 AC 0.5
VVB1 VB1 0 0.54
VVBN VBN 0 0.54
VVBP VBP 0 0.9900000000000001
VLABEL_NET_3 LABEL_NET_3 0 0.9

* Circuit
XMP21 VO VB0 N2 VDD sky130_fd_pr__pfet_01v8 l=0.5 w=5
XMN21 N0 VB1 N5 GND sky130_fd_pr__nfet_01v8 l=0.5 w=5
XMN1 N5 N0 GND GND sky130_fd_pr__nfet_01v8 l=0.5 w=5
XMP1 N2 VO VDD VDD sky130_fd_pr__pfet_01v8 l=0.5 w=5
XM2 VO VBN VBP N0 sky130_fd_pr__nfet_01v8 l=0.5 w=5
XM1 VO VBP VBP VDD sky130_fd_pr__pfet_01v8 l=0.5 w=5
XMN22 VO LABEL_NET_3 N5 GND sky130_fd_pr__nfet_01v8 l=0.5 w=5
XMP22 VO VDD N2 VDD sky130_fd_pr__pfet_01v8 l=0.5 w=5
CC VO GND 1p
CS VI GND 1p
CL N3 GND 1p
CC N0 GND 1p

.control
set filetype=ascii

op
let vdd_current = abs(i(VVDD))
let power_dc = vdd_current * 1.8
print power_dc

ac dec 100 1 10g
let vout_mag = vm(VO)
let gain_db = db(vout_mag)
let dc_gain_db = gain_db[0]
print dc_gain_db

if dc_gain_db > 0
    meas ac ugbw WHEN gain_db=0 CROSS=1
end

quit
.endc

.end
