* Testcase 000804 — Full Analysis (sky130 tt corner)
* SKY130 model header — replaces the ideal level-1 .model cards
* Ships with the demo; the paths point at the local sky130 PDK checkout.
* NOTE: libs.tech/ngspice/all.spice sets ".option scale=1.0u", so every
* instance L/W below is written in microns WITHOUT a "u" suffix.
.param mc_mm_switch=0
.param mc_pr_switch=0
.include /home/idies/workspace/Temporary/xyu1/scratch/skywater-pdk-libs-sky130_fd_pr/models/corners/tt.spice
.include /home/idies/workspace/Temporary/xyu1/scratch/skywater-pdk-libs-sky130_fd_pr/models/r+c/res_typical__cap_typical.spice
.include /home/idies/workspace/Temporary/xyu1/scratch/skywater-pdk-libs-sky130_fd_pr/models/r+c/res_typical__cap_typical__lin.spice
.include /home/idies/workspace/Temporary/xyu1/scratch/skywater-pdk-libs-sky130_fd_pr/models/corners/tt/specialized_cells.spice
.model DIDEAL D   is=1e-14 n=1
.options reltol=1e-3 itl1=500 itl2=100

* Sources
VVDD VDD 0 1.8
VIN IN 0 DC 0.9 AC 1 SIN(0.9 0.1 1MEG 0 0)
VINB INB 0 DC 0.9 AC 1 SIN(0.9 0.1 1MEG 0 0)

* Circuit
XM1 OUT N_MID VDD VDD sky130_fd_pr__pfet_01v8 l=0.5 w=5
XM5 OUTB N_MID VDD VDD sky130_fd_pr__pfet_01v8 l=0.5 w=5
R3 OUT N_MID 10k
R1 OUTB N_MID 10k
XM4 OUT LO N_SRC1 GND sky130_fd_pr__nfet_01v8 l=0.5 w=5
XM6 OUT LOB N_SRC1 GND sky130_fd_pr__nfet_01v8 l=0.5 w=5
XM2 OUTB LOB N_SRC2 GND sky130_fd_pr__nfet_01v8 l=0.5 w=5
XM8 OUTB LO N_SRC2 GND sky130_fd_pr__nfet_01v8 l=0.5 w=5
XM1 N_SRC1 A1_OUT AIN GND sky130_fd_pr__nfet_01v8 l=0.5 w=5
XM2 N_SRC2 A2_OUT AINB GND sky130_fd_pr__nfet_01v8 l=0.5 w=5
RIN AIN AINB 10k
I1 AIN GND 1u
I2 AINB GND 1u

.control
set filetype=ascii

op
let vdd_current = abs(i(VVDD))
let power_dc = vdd_current * 1.8
print power_dc

ac dec 100 1 10g
let vout_mag = vm(OUT)
let gain_db = db(vout_mag)
let dc_gain_db = gain_db[0]
print dc_gain_db

if dc_gain_db > 0
    meas ac ugbw WHEN gain_db=0 CROSS=1
end

quit
.endc

.end
