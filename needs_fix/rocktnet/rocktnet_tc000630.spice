* Testcase 000630 — Full Analysis (sky130 tt corner)
* SKY130 model header — replaces the ideal level-1 .model cards
* Ships with the demo; the paths point at the local sky130 PDK checkout.
* NOTE: libs.tech/ngspice/all.spice sets ".option scale=1.0u", so every
* instance L/W below is written in microns WITHOUT a "u" suffix.
.param mc_mm_switch=0
.param mc_pr_switch=0
.include /home/idies/workspace/Temporary/xyu1/scratch/skywater-pdk-libs-sky130_fd_pr/models/corners/tt.spice
.include /home/idies/workspace/Temporary/xyu1/scratch/skywater-pdk-libs-sky130_fd_pr/models/r+c/res_typical__cap_typical.spice
.include /home/idies/workspace/Temporary/xyu1/scratch/skywater-pdk-libs-sky130_fd_pr/models/r+c/res_typical__cap_typical__lin.spice
.include /home/idies/workspace/Temporary/xyu1/scratch/skywater-pdk-libs-sky130_fd_pr/models/corners/tt/specialized_cells.spice
.model DIDEAL D   is=1e-14 n=1
.options reltol=1e-3 itl1=500 itl2=100

* Sources
VVDD VDD 0 1.8

* Circuit
XM1 N_DR N_GR N_SR GND sky130_fd_pr__nfet_01v8 l=0.5 w=5
XM2 N_DL N_GL N_SL GND sky130_fd_pr__nfet_01v8 l=0.5 w=5
LVAR VVAR N_VARR 10n
LTANK VDD N_DL 10n
LVAR VVAR N_VARL 10n
LTANK VDD N_DR 10n
C2 N_SL N_COUT 1p
CVAR N_DR N_VARR 1p
C1 N_DL N_SL 1p
CG N_GL GND 1p
CVAR N_DL N_VARL 1p
C2 N_SR N_COUT 1p
COUT N_COUT VOUT 1p
CG N_GR GND 1p
C1 N_DR N_SR 1p
RS N_SR GND 10k
RS N_SL GND 10k
RG1 N_GR GND 10k
RG1 N_GL GND 10k
RG2 VDD N_GL 10k
RG2 VGBIAS N_GR 10k
D1 GND N_VARL DIDEAL
D2 GND N_VARR DIDEAL

.control
set filetype=ascii

op
let vdd_current = abs(i(VVDD))
let power_dc = vdd_current * 1.8
print power_dc

ac dec 100 1k 100g
let vout_mag = vm(VOUT)
let gain_db = db(vout_mag)

meas ac max_gain_db MAX gain_db
meas ac bw_3db WHEN gain_db='max_gain_db-3' CROSS=1

print max_gain_db bw_3db

quit
.endc

.end
