* Testcase 000201 — Full Analysis (sky130 tt corner)
* SKY130 model header — replaces the ideal level-1 .model cards
* Ships with the demo; the paths point at the local sky130 PDK checkout.
* NOTE: libs.tech/ngspice/all.spice sets ".option scale=1.0u", so every
* instance L/W below is written in microns WITHOUT a "u" suffix.
.param mc_mm_switch=0
.param mc_pr_switch=0
.include /home/idies/workspace/Temporary/xyu1/scratch/skywater-pdk-libs-sky130_fd_pr/models/corners/tt.spice
.include /home/idies/workspace/Temporary/xyu1/scratch/skywater-pdk-libs-sky130_fd_pr/models/r+c/res_typical__cap_typical.spice
.include /home/idies/workspace/Temporary/xyu1/scratch/skywater-pdk-libs-sky130_fd_pr/models/r+c/res_typical__cap_typical__lin.spice
.include /home/idies/workspace/Temporary/xyu1/scratch/skywater-pdk-libs-sky130_fd_pr/models/corners/tt/specialized_cells.spice
.model DIDEAL D   is=1e-14 n=1
.options reltol=1e-3 itl1=500 itl2=100

* Sources

* Circuit
R6 VCC N5 10k
R2 N1 VEE 10k
R3 VCC N9 10k
XQ1 N2 N13 VEE 0 sky130_fd_pr__npn_05v5_W1p00L1p00
R5 N7 VEE 10k
R4 VCC N6 10k
R6 N7 N5 10k
R7 N12 VEE 10k
XQ2 VCC V_L N7 0 sky130_fd_pr__npn_05v5_W1p00L1p00
XQ3 N7 N5 N8 0 sky130_fd_pr__npn_05v5_W1p00L1p00
R8 VEE VEE 10k
XQ4 N11 N7 N3 0 sky130_fd_pr__npn_05v5_W1p00L1p00
XQ16 N6 N0 N11 0 sky130_fd_pr__npn_05v5_W1p00L1p00
XQ7 N9 N6 N9 0 sky130_fd_pr__npn_05v5_W1p00L1p00
XQ9 VCC CLOCK N1 0 sky130_fd_pr__npn_05v5_W1p00L1p00
XQ8 N7 N6 N9 0 sky130_fd_pr__npn_05v5_W1p00L1p00
XQ8 N3 V_CS N12 0 sky130_fd_pr__npn_05v5_W1p00L1p00
XQ10 N5 N9 N7 0 sky130_fd_pr__npn_05v5_W1p00L1p00
XQ11 N8 N7 N2 0 sky130_fd_pr__npn_05v5_W1p00L1p00
XQ12 N9 DATA N11 0 sky130_fd_pr__npn_05v5_W1p00L1p00
XQ13 N9 N1 N3 0 sky130_fd_pr__npn_05v5_W1p00L1p00
XQ14 N5 N7 N8 0 sky130_fd_pr__npn_05v5_W1p00L1p00
XQ15 N9 N1 N2 0 sky130_fd_pr__npn_05v5_W1p00L1p00
XQ10 N6 N9 N9 0 sky130_fd_pr__npn_05v5_W1p00L1p00

.control
set filetype=ascii

op
let vdd_current = abs(i(VVDD))
let power_dc = vdd_current * 1.8
print power_dc

print all

quit
.endc

.end
