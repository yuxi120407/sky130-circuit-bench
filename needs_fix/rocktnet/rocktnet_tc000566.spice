* Testcase 000566 — Full Analysis (sky130 tt corner)
* SKY130 model header — replaces the ideal level-1 .model cards
* Ships with the demo; the paths point at the local sky130 PDK checkout.
* NOTE: libs.tech/ngspice/all.spice sets ".option scale=1.0u", so every
* instance L/W below is written in microns WITHOUT a "u" suffix.
.param mc_mm_switch=0
.param mc_pr_switch=0
.include /home/idies/workspace/Temporary/xyu1/scratch/skywater-pdk-libs-sky130_fd_pr/models/corners/tt.spice
.include /home/idies/workspace/Temporary/xyu1/scratch/skywater-pdk-libs-sky130_fd_pr/models/r+c/res_typical__cap_typical.spice
.include /home/idies/workspace/Temporary/xyu1/scratch/skywater-pdk-libs-sky130_fd_pr/models/r+c/res_typical__cap_typical__lin.spice
.include /home/idies/workspace/Temporary/xyu1/scratch/skywater-pdk-libs-sky130_fd_pr/models/corners/tt/specialized_cells.spice
.model DIDEAL D   is=1e-14 n=1
.options reltol=1e-3 itl1=500 itl2=100

* Sources
VVDD VDD 0 1.8
VVIN1_P VIN1_P 0 DC 0.9 AC 1 SIN(0.9 0.1 1MEG 0 0)
VVIN1_N VIN1_N 0 DC 0.9 AC 1 SIN(0.9 0.1 1MEG 0 0)
VIN3_P IN3_P 0 DC 0.9 AC 1 SIN(0.9 0.1 1MEG 0 0)
VIN3_N IN3_N 0 DC 0.9 AC 1 SIN(0.9 0.1 1MEG 0 0)

* Circuit
I1 VDD NET_TOP_R 1u
I2 NET_BOT GND 2u
I3 VDD NET_TOP_L 1u

.control
set filetype=ascii

op
let vdd_current = abs(i(VVDD))
let power_dc = vdd_current * 1.8
print power_dc

print all

quit
.endc

.end
