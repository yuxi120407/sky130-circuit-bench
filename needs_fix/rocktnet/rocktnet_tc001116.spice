* Testcase 001116 — Full Analysis (sky130 tt corner)
* SKY130 model header — replaces the ideal level-1 .model cards
* Ships with the demo; the paths point at the local sky130 PDK checkout.
* NOTE: libs.tech/ngspice/all.spice sets ".option scale=1.0u", so every
* instance L/W below is written in microns WITHOUT a "u" suffix.
.param mc_mm_switch=0
.param mc_pr_switch=0
.include /home/idies/workspace/Temporary/xyu1/scratch/skywater-pdk-libs-sky130_fd_pr/models/corners/tt.spice
.include /home/idies/workspace/Temporary/xyu1/scratch/skywater-pdk-libs-sky130_fd_pr/models/r+c/res_typical__cap_typical.spice
.include /home/idies/workspace/Temporary/xyu1/scratch/skywater-pdk-libs-sky130_fd_pr/models/r+c/res_typical__cap_typical__lin.spice
.include /home/idies/workspace/Temporary/xyu1/scratch/skywater-pdk-libs-sky130_fd_pr/models/corners/tt/specialized_cells.spice
.model DIDEAL D   is=1e-14 n=1
.options reltol=1e-3 itl1=500 itl2=100

* Sources
VVREF_NPN VREF_NPN 0 0.9
VVINPUT_P VINPUT_P 0 DC 0.9 AC 1 SIN(0.9 0.1 1MEG 0 0)
VVINPUT_N VINPUT_N 0 DC 0.9 AC 1 SIN(0.9 0.1 1MEG 0 0)
VVREF_PNP VREF_PNP 0 0.9
VVCM VCM 0 0.9

* Circuit
XQ16 N1 N29 N24 0 sky130_fd_pr__npn_05v5_W1p00L1p00
R1 VREF_NPN GND 10k
R2 N14 GND 10k
XQ_UNMAPPED_2 VOUTPUT_N GND VREF_NPN 0 sky130_fd_pr__npn_05v5_W1p00L1p00
XQ_UNMAPPED_3 VOUTPUT_P VREF_NPN N23 0 sky130_fd_pr__npn_05v5_W1p00L1p00
R3 N17 GND 10k
XQ9 GND N6 N2 sky130_fd_pr__pnp_05v5_W3p40L3p40
R4 N23 GND 10k
XQ5 N6 N1 N28 0 sky130_fd_pr__npn_05v5_W1p00L1p00
XQ12 N3 N4 VOUTPUT_N 0 sky130_fd_pr__npn_05v5_W1p00L1p00
R5 N28 GND 10k
R6 N16 GND 10k
XQ11 N3 N2 VOUTPUT_P 0 sky130_fd_pr__npn_05v5_W1p00L1p00
R7 N13 GND 10k
R8 N3 N3 10k
R9 N1 N5 10k
R10 N3 N3 10k
R11 N3 N3 10k
XQ_UNMAPPED_8 N1 VINPUT_P N10 sky130_fd_pr__pnp_05v5_W3p40L3p40
XQ18 N0 N1 N13 0 sky130_fd_pr__npn_05v5_W1p00L1p00
R12 N3 N3 10k
R13 N24 GND 10k
R14 N3 N3 10k
R15 N3 N3 10k
R16 N26 GND 10k
XQ15 N25 N9 N15 sky130_fd_pr__pnp_05v5_W3p40L3p40
XQ_UNMAPPED_11 N14 N25 N25 0 sky130_fd_pr__npn_05v5_W1p00L1p00
XQ10 GND N0 N4 sky130_fd_pr__pnp_05v5_W3p40L3p40
R17 N1 N7 10k
C2 N9 VOUTPUT_N 1p
R18 N3 N11 10k
XQ_UNMAPPED_13 N2 N19 N4 sky130_fd_pr__pnp_05v5_W3p40L3p40
XQ3 N1 N1 N16 0 sky130_fd_pr__npn_05v5_W1p00L1p00
C_UNMAPPED_2 N0 GND 1p
XQ_UNMAPPED_15 N10 N11 N12 sky130_fd_pr__pnp_05v5_W3p40L3p40
XQ1 N10 VINPUT_N N11 sky130_fd_pr__pnp_05v5_W3p40L3p40
R2 N9 VOUTPUT_N 10k
XQ2 N1 VINPUT_P N10 sky130_fd_pr__pnp_05v5_W3p40L3p40
C1 N9 VOUTPUT_P 1p
XQ7 N0 VREF_PNP N27 sky130_fd_pr__pnp_05v5_W3p40L3p40
XQ17 N1 N25 N26 0 sky130_fd_pr__npn_05v5_W1p00L1p00
XQ8 N6 N27 N18 sky130_fd_pr__pnp_05v5_W3p40L3p40
XQ21 N15 N12 VREF_PNP sky130_fd_pr__pnp_05v5_W3p40L3p40
R1 N9 VOUTPUT_P 10k
XQ13 N1 N1 N15 sky130_fd_pr__pnp_05v5_W3p40L3p40
C4 N6 GND 1p
XQ23 N4 N18 N19 sky130_fd_pr__pnp_05v5_W3p40L3p40
XQ4 N1 N1 N17 0 sky130_fd_pr__npn_05v5_W1p00L1p00
XQ14 N1 N1 N15 sky130_fd_pr__pnp_05v5_W3p40L3p40
C5 N6 N7 1p
C6 N0 N5 1p
R21 N1 VCM 10k

.control
set filetype=ascii

op
let vdd_current = abs(i(VVDD))
let power_dc = vdd_current * 1.8
print power_dc

ac dec 100 1 10g
let vout_mag = vm(VREF_NPN)
let gain_db = db(vout_mag)
let dc_gain_db = gain_db[0]
print dc_gain_db

if dc_gain_db > 0
    meas ac ugbw WHEN gain_db=0 CROSS=1
end

quit
.endc

.end
