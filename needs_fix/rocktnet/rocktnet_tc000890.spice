* Testcase 000890 — Full Analysis (sky130 tt corner)
* SKY130 model header — replaces the ideal level-1 .model cards
* Ships with the demo; the paths point at the local sky130 PDK checkout.
* NOTE: libs.tech/ngspice/all.spice sets ".option scale=1.0u", so every
* instance L/W below is written in microns WITHOUT a "u" suffix.
.param mc_mm_switch=0
.param mc_pr_switch=0
.include /home/idies/workspace/Temporary/xyu1/scratch/skywater-pdk-libs-sky130_fd_pr/models/corners/tt.spice
.include /home/idies/workspace/Temporary/xyu1/scratch/skywater-pdk-libs-sky130_fd_pr/models/r+c/res_typical__cap_typical.spice
.include /home/idies/workspace/Temporary/xyu1/scratch/skywater-pdk-libs-sky130_fd_pr/models/r+c/res_typical__cap_typical__lin.spice
.include /home/idies/workspace/Temporary/xyu1/scratch/skywater-pdk-libs-sky130_fd_pr/models/corners/tt/specialized_cells.spice
.model DIDEAL D   is=1e-14 n=1
.options reltol=1e-2 abstol=1e-10 vntol=1e-4 itl1=1000 itl2=200 itl4=100
.options gmin=1e-10 method=gear

* Sources

* Circuit
XQ1 N1 A_P N3 0 sky130_fd_pr__npn_05v5_W1p00L1p00
XQ2 N3 N5 N7 0 sky130_fd_pr__npn_05v5_W1p00L1p00
XQ3 N2 B_N N4 0 sky130_fd_pr__npn_05v5_W1p00L1p00
XQ4 N2 A_N N3 0 sky130_fd_pr__npn_05v5_W1p00L1p00
XQ5 GND VC_N N6 0 sky130_fd_pr__npn_05v5_W1p00L1p00
XQ6 N4 N6 N8 0 sky130_fd_pr__npn_05v5_W1p00L1p00
XQ7 N8 BIAS N12 0 sky130_fd_pr__npn_05v5_W1p00L1p00
XQ8 N7 BIAS N11 0 sky130_fd_pr__npn_05v5_W1p00L1p00
XQ9 N5 BIAS N9 0 sky130_fd_pr__npn_05v5_W1p00L1p00
XQ10 N6 BIAS N10 0 sky130_fd_pr__npn_05v5_W1p00L1p00
XQ11 GND N1 OUT_P 0 sky130_fd_pr__npn_05v5_W1p00L1p00
XQ12 N1 B_P N4 0 sky130_fd_pr__npn_05v5_W1p00L1p00
XQ13 GND N2 OUT_N 0 sky130_fd_pr__npn_05v5_W1p00L1p00
XQ14 GND VC_P N5 0 sky130_fd_pr__npn_05v5_W1p00L1p00
R1 GND N1 10k
R2 GND N2 10k
R3 N9 VEE 10k
R4 N10 VEE 10k
R5 N11 VEE 10k
R6 N12 VEE 10k
R7 OUT_N VEE 10k
R8 OUT_P VEE 10k
R9 N7 N8 10k

.control
set filetype=ascii

op

let dc_voltage = v(N1)
print dc_voltage
print all

quit
.endc

.end
