* Testcase 000549 — Full Analysis (sky130 tt corner)
* SKY130 model header — replaces the ideal level-1 .model cards
* Ships with the demo; the paths point at the local sky130 PDK checkout.
* NOTE: libs.tech/ngspice/all.spice sets ".option scale=1.0u", so every
* instance L/W below is written in microns WITHOUT a "u" suffix.
.param mc_mm_switch=0
.param mc_pr_switch=0
.include /home/idies/workspace/Temporary/xyu1/scratch/skywater-pdk-libs-sky130_fd_pr/models/corners/tt.spice
.include /home/idies/workspace/Temporary/xyu1/scratch/skywater-pdk-libs-sky130_fd_pr/models/r+c/res_typical__cap_typical.spice
.include /home/idies/workspace/Temporary/xyu1/scratch/skywater-pdk-libs-sky130_fd_pr/models/r+c/res_typical__cap_typical__lin.spice
.include /home/idies/workspace/Temporary/xyu1/scratch/skywater-pdk-libs-sky130_fd_pr/models/corners/tt/specialized_cells.spice
.model DIDEAL D   is=1e-14 n=1
.options reltol=1e-2 abstol=1e-10 vntol=1e-4 itl1=1000 itl2=200 itl4=100
.options gmin=1e-10 method=gear

* Sources

* Circuit
R1 VCC X 10k
R2 VCC Y 10k
C1 X GND 1p
C2 Y GND 1p
XQ1 N1 CKOUT_N N3 0 sky130_fd_pr__npn_05v5_W1p00L1p00
XQ2 N2 CKOUT_P N3 0 sky130_fd_pr__npn_05v5_W1p00L1p00
XQ3 Y CKIN_N N1 0 sky130_fd_pr__npn_05v5_W1p00L1p00
XQ4 X CKIN_N N2 0 sky130_fd_pr__npn_05v5_W1p00L1p00
XQ5 X CKIN_P N1 0 sky130_fd_pr__npn_05v5_W1p00L1p00
XQ6 Y CKIN_P N2 0 sky130_fd_pr__npn_05v5_W1p00L1p00
XQ7 VCC X CKOUT_P 0 sky130_fd_pr__npn_05v5_W1p00L1p00
XQ8 VCC Y CKOUT_N 0 sky130_fd_pr__npn_05v5_W1p00L1p00
I1 CKOUT_P GND 1u
I2 N3 GND 1u
I3 CKOUT_N GND 1u

.control
set filetype=ascii

op

let dc_voltage = v(VCC)
print dc_voltage
print all

quit
.endc

.end
