* Testcase 000255 — Full Analysis (sky130 tt corner)
* SKY130 model header — replaces the ideal level-1 .model cards
* Ships with the demo; the paths point at the local sky130 PDK checkout.
* NOTE: libs.tech/ngspice/all.spice sets ".option scale=1.0u", so every
* instance L/W below is written in microns WITHOUT a "u" suffix.
.param mc_mm_switch=0
.param mc_pr_switch=0
.include /home/idies/workspace/Temporary/xyu1/scratch/skywater-pdk-libs-sky130_fd_pr/models/corners/tt.spice
.include /home/idies/workspace/Temporary/xyu1/scratch/skywater-pdk-libs-sky130_fd_pr/models/r+c/res_typical__cap_typical.spice
.include /home/idies/workspace/Temporary/xyu1/scratch/skywater-pdk-libs-sky130_fd_pr/models/r+c/res_typical__cap_typical__lin.spice
.include /home/idies/workspace/Temporary/xyu1/scratch/skywater-pdk-libs-sky130_fd_pr/models/corners/tt/specialized_cells.spice
.model DIDEAL D   is=1e-14 n=1
.options reltol=1e-3 itl1=500 itl2=100

* Sources
VVDD VDD 0 1.8
VVB4 VB4 0 0.54
VVCM VCM 0 0.9
VVB2 VB2 0 0.9900000000000001
VIN_PLUS IN_PLUS 0 DC 0.9 AC 1 SIN(0.9 0.1 1MEG 0 0)
VVB3 VB3 0 0.54
VVB1 VB1 0 0.9900000000000001
VIN_MINUS IN_MINUS 0 DC 0.9 AC 1 SIN(0.9 0.1 1MEG 0 0)

* Circuit
XT3P NET_T4P_S NET_T4CM_S GND GND sky130_fd_pr__nfet_01v8 l=0.5 w=5
XT11 NET_T11_D VB4 GND GND sky130_fd_pr__nfet_01v8 l=0.5 w=5
XT4CM NET_T4CM_D NET_T4CM_D NET_T4CM_S GND sky130_fd_pr__nfet_01v8 l=0.5 w=5
XT3CM NET_T4CM_S VCM GND GND sky130_fd_pr__nfet_01v8 l=0.5 w=5
XT1 NET_T1_D VB2 NET_T0_D VDD sky130_fd_pr__pfet_01v8 l=0.5 w=5
XT9P NET_T11_D NET_T11_D NET_T8P_D VDD sky130_fd_pr__pfet_01v8 l=0.5 w=5
XT2 NET_T4_S IN_PLUS NET_T1_D VDD sky130_fd_pr__pfet_01v8 l=0.5 w=5
XT4P NET_T5P_S NET_T4CM_D NET_T4P_S GND sky130_fd_pr__nfet_01v8 l=0.5 w=5
XT6 OUT_MINUS OUT_MINUS NET_T7_D VDD sky130_fd_pr__pfet_01v8 l=0.5 w=5
XT5 OUT_MINUS VB3 NET_T5_S GND sky130_fd_pr__nfet_01v8 l=0.5 w=5
XT8P NET_T8P_D NET_T8P_D NET_T9PTOP_D VDD sky130_fd_pr__pfet_01v8 l=0.5 w=5
XT13 NET_T4CM_D VB2 NET_T12_D VDD sky130_fd_pr__pfet_01v8 l=0.5 w=5
XT9PTOP NET_T9PTOP_D VB2 NET_T10P_D VDD sky130_fd_pr__pfet_01v8 l=0.5 w=5
XT10P NET_T10P_D VB1 VDD VDD sky130_fd_pr__pfet_01v8 l=0.5 w=5
XT3 NET_T4_S NET_T4CM_S GND GND sky130_fd_pr__nfet_01v8 l=0.5 w=5
XT12 NET_T12_D VB1 VDD VDD sky130_fd_pr__pfet_01v8 l=0.5 w=5
XT5P OUT_PLUS VB3 NET_T5P_S GND sky130_fd_pr__nfet_01v8 l=0.5 w=5
XT7 NET_T7_D NET_T7_D NET_T9TOP_D VDD sky130_fd_pr__pfet_01v8 l=0.5 w=5
XT0 NET_T0_D VB1 VDD VDD sky130_fd_pr__pfet_01v8 l=0.5 w=5
XT10 NET_T10_D VB1 VDD VDD sky130_fd_pr__pfet_01v8 l=0.5 w=5
XT9 NET_T11_D NET_T11_D NET_T8_D VDD sky130_fd_pr__pfet_01v8 l=0.5 w=5
XT6P OUT_PLUS OUT_PLUS NET_T7P_D VDD sky130_fd_pr__pfet_01v8 l=0.5 w=5
XT4 NET_T5_S NET_T4CM_D NET_T4_S GND sky130_fd_pr__nfet_01v8 l=0.5 w=5
XT7P NET_T7P_D NET_T7P_D NET_T9PTOP_D VDD sky130_fd_pr__pfet_01v8 l=0.5 w=5
XT8 NET_T8_D NET_T8_D NET_T9TOP_D VDD sky130_fd_pr__pfet_01v8 l=0.5 w=5
XT9TOP NET_T9TOP_D VB2 NET_T10_D VDD sky130_fd_pr__pfet_01v8 l=0.5 w=5
XT2P NET_T4P_S IN_MINUS NET_T1_D VDD sky130_fd_pr__pfet_01v8 l=0.5 w=5

.control
set filetype=ascii

op
let vdd_current = abs(i(VVDD))
let power_dc = vdd_current * 1.8
print power_dc

print all

quit
.endc

.end
