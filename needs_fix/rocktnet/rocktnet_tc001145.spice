* Testcase 001145 — Full Analysis (sky130 tt corner)
* SKY130 model header — replaces the ideal level-1 .model cards
* Ships with the demo; the paths point at the local sky130 PDK checkout.
* NOTE: libs.tech/ngspice/all.spice sets ".option scale=1.0u", so every
* instance L/W below is written in microns WITHOUT a "u" suffix.
.param mc_mm_switch=0
.param mc_pr_switch=0
.include /home/idies/workspace/Temporary/xyu1/scratch/skywater-pdk-libs-sky130_fd_pr/models/corners/tt.spice
.include /home/idies/workspace/Temporary/xyu1/scratch/skywater-pdk-libs-sky130_fd_pr/models/r+c/res_typical__cap_typical.spice
.include /home/idies/workspace/Temporary/xyu1/scratch/skywater-pdk-libs-sky130_fd_pr/models/r+c/res_typical__cap_typical__lin.spice
.include /home/idies/workspace/Temporary/xyu1/scratch/skywater-pdk-libs-sky130_fd_pr/models/corners/tt/specialized_cells.spice
.model DIDEAL D   is=1e-14 n=1
.options reltol=1e-3 itl1=500 itl2=100

* Sources

* Circuit
I_BD D B 1u
I_BS S B 1u
I_GS G S 1u
I_M N1 B 1u
I_DS S D 1u
I_C S D 1u
C_D_SUB D GND 1p
I_GD G N1 1u
C_GB G N6 1p
C_GS G N5 1p
C_DB N0 B 1p
C_B_SUB B GND 1p
C_GD N0 G 1p
C_SB N5 B 1p
C_S_SUB S GND 1p
XQ1 B S N6 sky130_fd_pr__pnp_05v5_W3p40L3p40

.control
set filetype=ascii

ac dec 100 1 10g
let vout_mag = vm(D)
let gain_db = db(vout_mag)

meas ac max_gain_db MAX gain_db
meas ac bw_3db WHEN gain_db='max_gain_db-3' CROSS=1

print max_gain_db bw_3db

quit
.endc

.end
