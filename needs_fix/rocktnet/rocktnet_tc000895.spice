* Testcase 000895 — Full Analysis (sky130 tt corner)
* SKY130 model header — replaces the ideal level-1 .model cards
* Ships with the demo; the paths point at the local sky130 PDK checkout.
* NOTE: libs.tech/ngspice/all.spice sets ".option scale=1.0u", so every
* instance L/W below is written in microns WITHOUT a "u" suffix.
.param mc_mm_switch=0
.param mc_pr_switch=0
.include /home/idies/workspace/Temporary/xyu1/scratch/skywater-pdk-libs-sky130_fd_pr/models/corners/tt.spice
.include /home/idies/workspace/Temporary/xyu1/scratch/skywater-pdk-libs-sky130_fd_pr/models/r+c/res_typical__cap_typical.spice
.include /home/idies/workspace/Temporary/xyu1/scratch/skywater-pdk-libs-sky130_fd_pr/models/r+c/res_typical__cap_typical__lin.spice
.include /home/idies/workspace/Temporary/xyu1/scratch/skywater-pdk-libs-sky130_fd_pr/models/corners/tt/specialized_cells.spice
.model DIDEAL D   is=1e-14 n=1
.options reltol=1e-3 itl1=500 itl2=100

* Sources

* Circuit
R10 VCC N_C1 10k
R9 VCC N_C2 10k
R14 VCC N_C3 10k
R11 VCC N_C4 10k
R8 QXN N_BIAS_M 10k
R1 QX N_BIAS_M 10k
R12 Q N_BIAS_S 10k
R2 QN N_BIAS_S 10k
R6 N_E_TAIL1 VEE 10k
R3 N_E_TAIL2 VEE 10k
R4 N_E_TAIL3 VEE 10k
R13 N_E_TAIL4 VEE 10k
XQ20 VCC N_C1 QXN 0 sky130_fd_pr__npn_05v5_W1p00L1p00
XQ11 VCC N_C2 QX 0 sky130_fd_pr__npn_05v5_W1p00L1p00
XQ15 N_C1 D N_E1 0 sky130_fd_pr__npn_05v5_W1p00L1p00
XQ12 N_C2 DN N_E1 0 sky130_fd_pr__npn_05v5_W1p00L1p00
XQ13 N_C2 QXN N_E2 0 sky130_fd_pr__npn_05v5_W1p00L1p00
XQ3 N_C1 QX N_E2 0 sky130_fd_pr__npn_05v5_W1p00L1p00
XQ10 N_E1 CLK N_TAIL_M 0 sky130_fd_pr__npn_05v5_W1p00L1p00
XQ16 N_E2 CLKN N_TAIL_M 0 sky130_fd_pr__npn_05v5_W1p00L1p00
XQ1 N_TAIL_M N_BIAS_M N_E_TAIL1 0 sky130_fd_pr__npn_05v5_W1p00L1p00
XQ4 N_BIAS_M N_BIAS_M N_E_TAIL2 0 sky130_fd_pr__npn_05v5_W1p00L1p00
XQ19 VCC N_C3 Q 0 sky130_fd_pr__npn_05v5_W1p00L1p00
XQ7 VCC N_C4 QN 0 sky130_fd_pr__npn_05v5_W1p00L1p00
XQ14 N_C3 QX N_E3 0 sky130_fd_pr__npn_05v5_W1p00L1p00
XQ9 N_C4 QXN N_E3 0 sky130_fd_pr__npn_05v5_W1p00L1p00
XQ17 N_C4 Q N_E4 0 sky130_fd_pr__npn_05v5_W1p00L1p00
XQ6 N_C3 QN N_E4 0 sky130_fd_pr__npn_05v5_W1p00L1p00
XQ18 N_E3 CLKN N_TAIL_S 0 sky130_fd_pr__npn_05v5_W1p00L1p00
XQ8 N_E4 CLK N_TAIL_S 0 sky130_fd_pr__npn_05v5_W1p00L1p00
XQ2 N_TAIL_S N_BIAS_S N_E_TAIL3 0 sky130_fd_pr__npn_05v5_W1p00L1p00
XQ5 N_BIAS_S N_BIAS_S N_E_TAIL4 0 sky130_fd_pr__npn_05v5_W1p00L1p00

.control
set filetype=ascii

op
let vdd_current = abs(i(VVDD))
let power_dc = vdd_current * 1.8
print power_dc

print all

quit
.endc

.end
