* Testcase 000635 — Full Analysis (sky130 tt corner)
* SKY130 model header — replaces the ideal level-1 .model cards
* Ships with the demo; the paths point at the local sky130 PDK checkout.
* NOTE: libs.tech/ngspice/all.spice sets ".option scale=1.0u", so every
* instance L/W below is written in microns WITHOUT a "u" suffix.
.param mc_mm_switch=0
.param mc_pr_switch=0
.include /home/idies/workspace/Temporary/xyu1/scratch/skywater-pdk-libs-sky130_fd_pr/models/corners/tt.spice
.include /home/idies/workspace/Temporary/xyu1/scratch/skywater-pdk-libs-sky130_fd_pr/models/r+c/res_typical__cap_typical.spice
.include /home/idies/workspace/Temporary/xyu1/scratch/skywater-pdk-libs-sky130_fd_pr/models/r+c/res_typical__cap_typical__lin.spice
.include /home/idies/workspace/Temporary/xyu1/scratch/skywater-pdk-libs-sky130_fd_pr/models/corners/tt/specialized_cells.spice
.model DIDEAL D   is=1e-14 n=1
.options reltol=1e-3 itl1=500 itl2=100

* Sources
VVDD VDD 0 1.8
VVSS VSS 0 0

* Circuit
I1 BO VSS 1u
I2 N13 VSS 1u
I3 N0 VSS 1u
I4 N6 VSS 1u
I5 N11 VSS 1u
I6 N4 VSS 1u
I7 N8 VSS 1u
I8 N12 VSS 1u
XQ1 VDD N5 N8 0 sky130_fd_pr__npn_05v5_W1p00L1p00
XQ2 N7 N13 N4 0 sky130_fd_pr__npn_05v5_W1p00L1p00
XQ3 N9 TB N11 0 sky130_fd_pr__npn_05v5_W1p00L1p00
XQ4 N5 N12 N0 0 sky130_fd_pr__npn_05v5_W1p00L1p00
XQ5 N9 TA N4 0 sky130_fd_pr__npn_05v5_W1p00L1p00
XQ6 VDD N10 BO 0 sky130_fd_pr__npn_05v5_W1p00L1p00
XQ7 N10 N13 N0 0 sky130_fd_pr__npn_05v5_W1p00L1p00
XQ8 N9 TC N6 0 sky130_fd_pr__npn_05v5_W1p00L1p00
XQ9 VDD N9 N12 0 sky130_fd_pr__npn_05v5_W1p00L1p00
XQ10 N7 N13 N6 0 sky130_fd_pr__npn_05v5_W1p00L1p00
XQ11 VDD N7 N13 0 sky130_fd_pr__npn_05v5_W1p00L1p00
XQ12 N7 N13 N11 0 sky130_fd_pr__npn_05v5_W1p00L1p00
R1 VDD N7 10k
R2 VDD N5 10k
R3 VDD N9 10k
R4 VDD N10 10k

.control
set filetype=ascii

op
let vdd_current = abs(i(VVDD))
let power_dc = vdd_current * 1.8
print power_dc

print all

quit
.endc

.end
