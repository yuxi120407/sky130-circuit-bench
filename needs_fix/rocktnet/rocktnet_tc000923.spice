* Testcase 000923 — Full Analysis (sky130 tt corner)
* SKY130 model header — replaces the ideal level-1 .model cards
* Ships with the demo; the paths point at the local sky130 PDK checkout.
* NOTE: libs.tech/ngspice/all.spice sets ".option scale=1.0u", so every
* instance L/W below is written in microns WITHOUT a "u" suffix.
.param mc_mm_switch=0
.param mc_pr_switch=0
.include /home/idies/workspace/Temporary/xyu1/scratch/skywater-pdk-libs-sky130_fd_pr/models/corners/tt.spice
.include /home/idies/workspace/Temporary/xyu1/scratch/skywater-pdk-libs-sky130_fd_pr/models/r+c/res_typical__cap_typical.spice
.include /home/idies/workspace/Temporary/xyu1/scratch/skywater-pdk-libs-sky130_fd_pr/models/r+c/res_typical__cap_typical__lin.spice
.include /home/idies/workspace/Temporary/xyu1/scratch/skywater-pdk-libs-sky130_fd_pr/models/corners/tt/specialized_cells.spice
.model DIDEAL D   is=1e-14 n=1
.options reltol=1e-3 itl1=500 itl2=100

* Sources
VVDD VDD 0 1.8
VLABEL_NET_0 LABEL_NET_0 0 0.9
VLABEL_NET_1 LABEL_NET_1 0 0.9
VLABEL_NET_2 LABEL_NET_2 0 0.9

* Circuit
XM1 N2 N2 N0 VDD sky130_fd_pr__pfet_01v8 l=0.5 w=5
XM2 N0 N0 N6 VDD sky130_fd_pr__pfet_01v8 l=0.5 w=5
XM3 N2 N2 N0 VDD sky130_fd_pr__pfet_01v8 l=0.5 w=5
XM4 N0 N0 N11 VDD sky130_fd_pr__pfet_01v8 l=0.5 w=5
XM4 N3 N0 N11 VDD sky130_fd_pr__pfet_01v8 l=0.5 w=5
I1 N5 GND 1u
XM3 N16 N0 N6 VDD sky130_fd_pr__pfet_01v8 l=0.5 w=5
XM7 N7 VCOMMON N15 GND sky130_fd_pr__nfet_01v8 l=0.5 w=5
I2 N13 GND 1u
XM1 N0 N12 N4 GND sky130_fd_pr__nfet_01v8 l=0.5 w=5
I3 N4 GND 1u
XM9 N2 N2 N3 VDD sky130_fd_pr__pfet_01v8 l=0.5 w=5
XM2 N0 N0 LABEL_NET_0 VDD sky130_fd_pr__pfet_01v8 l=0.5 w=5
XM11 N2 N2 N0 VDD sky130_fd_pr__pfet_01v8 l=0.5 w=5
XM12 N8 VCOMMON N13 GND sky130_fd_pr__nfet_01v8 l=0.5 w=5
XM13 N2 Q N16 VDD sky130_fd_pr__pfet_01v8 l=0.5 w=5
XM14 N12 N4 N15 GND sky130_fd_pr__nfet_01v8 l=0.5 w=5
R1 N2 GND 10k
XM15 N2 I N3 VDD sky130_fd_pr__pfet_01v8 l=0.5 w=5
I4 N15 GND 1u
XM16 VDD N7 VDD GND sky130_fd_pr__nfet_01v8 l=0.5 w=5
XM17 N2 I N2 VDD sky130_fd_pr__pfet_01v8 l=0.5 w=5
I5 VDD N11 1u
R2 N2 GND 10k
R3 N2 GND 10k
XM18 N2 Q N0 VDD sky130_fd_pr__pfet_01v8 l=0.5 w=5
XM19 N0 N9 N5 GND sky130_fd_pr__nfet_01v8 l=0.5 w=5
R4 N2 GND 10k
XM20 N9 N5 GND GND sky130_fd_pr__nfet_01v8 l=0.5 w=5
XM21 N0 N0 LABEL_NET_1 VDD sky130_fd_pr__pfet_01v8 l=0.5 w=5
I6 VDD N6 1u
XM22 VDD N7 N7 GND sky130_fd_pr__nfet_01v8 l=0.5 w=5
XM23 N9 N8 N8 GND sky130_fd_pr__nfet_01v8 l=0.5 w=5
XM24 LABEL_NET_2 N8 N9 GND sky130_fd_pr__nfet_01v8 l=0.5 w=5
VX N4 GND 0

.control
set filetype=ascii

op
let vdd_current = abs(i(VVDD))
let power_dc = vdd_current * 1.8
let vout_dc = v(N2)
print power_dc vout_dc

quit
.endc

.end
