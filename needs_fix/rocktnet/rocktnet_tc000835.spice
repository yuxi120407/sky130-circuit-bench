* Testcase 000835 — Full Analysis (sky130 tt corner)
* SKY130 model header — replaces the ideal level-1 .model cards
* Ships with the demo; the paths point at the local sky130 PDK checkout.
* NOTE: libs.tech/ngspice/all.spice sets ".option scale=1.0u", so every
* instance L/W below is written in microns WITHOUT a "u" suffix.
.param mc_mm_switch=0
.param mc_pr_switch=0
.include /home/idies/workspace/Temporary/xyu1/scratch/skywater-pdk-libs-sky130_fd_pr/models/corners/tt.spice
.include /home/idies/workspace/Temporary/xyu1/scratch/skywater-pdk-libs-sky130_fd_pr/models/r+c/res_typical__cap_typical.spice
.include /home/idies/workspace/Temporary/xyu1/scratch/skywater-pdk-libs-sky130_fd_pr/models/r+c/res_typical__cap_typical__lin.spice
.include /home/idies/workspace/Temporary/xyu1/scratch/skywater-pdk-libs-sky130_fd_pr/models/corners/tt/specialized_cells.spice
.model DIDEAL D   is=1e-14 n=1
.options reltol=1e-3 itl1=500 itl2=100

* Sources
VVDD VDD 0 1.8

* Circuit
I1 N3 GND 1u
I2 N1 GND 1u
I3 N6 GND 1u
I4 N0 GND 1u
I5 N2 GND 1u
I6 N5 GND 1u
XQ10 VDD Y1_N N3 0 sky130_fd_pr__npn_05v5_W1p00L1p00
XQ12 VDD Y2_N N6 0 sky130_fd_pr__npn_05v5_W1p00L1p00
XQ16 VDD Y4_N N2 0 sky130_fd_pr__npn_05v5_W1p00L1p00
XQ14 VDD Y3_N N1 0 sky130_fd_pr__npn_05v5_W1p00L1p00
XQ18 VDD Y5_N N5 0 sky130_fd_pr__npn_05v5_W1p00L1p00
XQ13 ICOMP Y3_P N1 0 sky130_fd_pr__npn_05v5_W1p00L1p00
XQ19 ICOMP Y6_P N0 0 sky130_fd_pr__npn_05v5_W1p00L1p00
XQ9 ICOMP Y1_P N3 0 sky130_fd_pr__npn_05v5_W1p00L1p00
XQ17 ICOMP Y5_P N5 0 sky130_fd_pr__npn_05v5_W1p00L1p00
XQ20 VDD Y6_N N0 0 sky130_fd_pr__npn_05v5_W1p00L1p00
XQ11 ICOMP Y2_P N6 0 sky130_fd_pr__npn_05v5_W1p00L1p00
XQ15 ICOMP Y4_P N2 0 sky130_fd_pr__npn_05v5_W1p00L1p00

.control
set filetype=ascii

op
let vdd_current = abs(i(VVDD))
let power_dc = vdd_current * 1.8
print power_dc

print all

quit
.endc

.end
