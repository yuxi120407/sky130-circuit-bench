* Testcase 000774 — Full Analysis (sky130 tt corner)
* SKY130 model header — replaces the ideal level-1 .model cards
* Ships with the demo; the paths point at the local sky130 PDK checkout.
* NOTE: libs.tech/ngspice/all.spice sets ".option scale=1.0u", so every
* instance L/W below is written in microns WITHOUT a "u" suffix.
.param mc_mm_switch=0
.param mc_pr_switch=0
.include /home/idies/workspace/Temporary/xyu1/scratch/skywater-pdk-libs-sky130_fd_pr/models/corners/tt.spice
.include /home/idies/workspace/Temporary/xyu1/scratch/skywater-pdk-libs-sky130_fd_pr/models/r+c/res_typical__cap_typical.spice
.include /home/idies/workspace/Temporary/xyu1/scratch/skywater-pdk-libs-sky130_fd_pr/models/r+c/res_typical__cap_typical__lin.spice
.include /home/idies/workspace/Temporary/xyu1/scratch/skywater-pdk-libs-sky130_fd_pr/models/corners/tt/specialized_cells.spice
.model DIDEAL D   is=1e-14 n=1
.options reltol=1e-3 itl1=500 itl2=100

* Sources
VLABEL_NET_0 LABEL_NET_0 0 0.9
VLABEL_NET_1 LABEL_NET_1 0 0.9
VLABEL_NET_2 LABEL_NET_2 0 0.9
VLABEL_NET_3 LABEL_NET_3 0 0.9
VLABEL_NET_4 LABEL_NET_4 0 0.9
VLABEL_NET_5 LABEL_NET_5 0 0.9
VLABEL_NET_6 LABEL_NET_6 0 0.9
VLABEL_NET_7 LABEL_NET_7 0 0.9
VLABEL_NET_8 LABEL_NET_8 0 0.9
VLABEL_NET_9 LABEL_NET_9 0 0.9

* Circuit
XM1 N2 LABEL_NET_0 N6 GND sky130_fd_pr__nfet_01v8 l=0.5 w=5
XM2 N2 LABEL_NET_1 VP_N GND sky130_fd_pr__nfet_01v8 l=0.5 w=5
XM3 N2 LABEL_NET_2 VP GND sky130_fd_pr__nfet_01v8 l=0.5 w=5
XM4 N2 LABEL_NET_3 VP_N GND sky130_fd_pr__nfet_01v8 l=0.5 w=5
XM5 N2 LABEL_NET_4 VP_1 GND sky130_fd_pr__nfet_01v8 l=0.5 w=5
R1 N3 N9 10k
R2 N3 N12 10k
R3 N0 VN_1 10k
R4 N3 VN_1 10k
R5 N3 VP 10k
XM6 VN_N LABEL_NET_5 N8 GND sky130_fd_pr__nfet_01v8 l=0.5 w=5
R6 VN_N N3 10k
R7 N3 VP_N 10k
R8 N3 VN 10k
R9 VN VN_1 10k
XM7 VN_1 LABEL_NET_6 N8 GND sky130_fd_pr__nfet_01v8 l=0.5 w=5
R10 VN_N N3 10k
R11 N3 VP_N 10k
R12 N3 VP_1 10k
R13 N3 N6 10k
ZBIAS N3 GND 10k
R15 N0 VN_N 10k
XM8 VN LABEL_NET_7 N8 GND sky130_fd_pr__nfet_01v8 l=0.5 w=5
R16 N6 VP_1 10k
R17 VP VP_1 10k
XM9 N0 LABEL_NET_8 N8 GND sky130_fd_pr__nfet_01v8 l=0.5 w=5
R18 VN_N N9 10k
R19 N0 N3 10k
R20 VP_N N12 10k
XM10 VN_N LABEL_NET_9 N8 GND sky130_fd_pr__nfet_01v8 l=0.5 w=5
R21 N6 VP_N 10k

.control
set filetype=ascii

op
let vdd_current = abs(i(VVDD))
let power_dc = vdd_current * 1.8
print power_dc

print all

quit
.endc

.end
