* Testcase 000899 — Full Analysis (sky130 tt corner)
* SKY130 model header — replaces the ideal level-1 .model cards
* Ships with the demo; the paths point at the local sky130 PDK checkout.
* NOTE: libs.tech/ngspice/all.spice sets ".option scale=1.0u", so every
* instance L/W below is written in microns WITHOUT a "u" suffix.
.param mc_mm_switch=0
.param mc_pr_switch=0
.include /home/idies/workspace/Temporary/xyu1/scratch/skywater-pdk-libs-sky130_fd_pr/models/corners/tt.spice
.include /home/idies/workspace/Temporary/xyu1/scratch/skywater-pdk-libs-sky130_fd_pr/models/r+c/res_typical__cap_typical.spice
.include /home/idies/workspace/Temporary/xyu1/scratch/skywater-pdk-libs-sky130_fd_pr/models/r+c/res_typical__cap_typical__lin.spice
.include /home/idies/workspace/Temporary/xyu1/scratch/skywater-pdk-libs-sky130_fd_pr/models/corners/tt/specialized_cells.spice
.model DIDEAL D   is=1e-14 n=1
.options reltol=1e-3 itl1=500 itl2=100

* Sources
VVDD VDD 0 1.8
VVBIAS VBIAS 0 0.54
VVCONTROLn VCONTROLn 0 0.9
VVINp VINp 0 DC 0.9 AC 1 SIN(0.9 0.1 1MEG 0 0)
VVCONTROLp VCONTROLp 0 0.9
VVINn VINn 0 DC 0.9 AC 1 SIN(0.9 0.1 1MEG 0 0)
VVREF VREF 0 0.9

* Circuit
XM1 N_ISS1 VBIAS GND GND sky130_fd_pr__nfet_01v8 l=0.5 w=5
XM2 N_ISS3 VBIAS GND GND sky130_fd_pr__nfet_01v8 l=0.5 w=5
XM3 N_ISS2 VBIAS GND GND sky130_fd_pr__nfet_01v8 l=0.5 w=5
XM1 VCONTROLn VINp N_ISS1 GND sky130_fd_pr__nfet_01v8 l=0.5 w=5
XM2 VCONTROLp N_CMFB VDD VDD sky130_fd_pr__pfet_01v8 l=0.5 w=5
XM1 VCONTROLp VINn N_ISS1 GND sky130_fd_pr__nfet_01v8 l=0.5 w=5
XM2 VCONTROLn N_CMFB VDD VDD sky130_fd_pr__pfet_01v8 l=0.5 w=5
XM8 VDD VCONTROLp N_ISS2 GND sky130_fd_pr__nfet_01v8 l=0.5 w=5
XM9 VDD VCONTROLn N_ISS3 GND sky130_fd_pr__nfet_01v8 l=0.5 w=5
XM10 N_CMFB VREF N_ISS3 GND sky130_fd_pr__nfet_01v8 l=0.5 w=5
XM11 N_CMFB VREF N_ISS2 GND sky130_fd_pr__nfet_01v8 l=0.5 w=5
XM12 N_CMFB N_CMFB VDD VDD sky130_fd_pr__pfet_01v8 l=0.5 w=5
CL VCONTROLn GND 1p
CL VCONTROLp GND 1p

.control
set filetype=ascii

op
let vdd_current = abs(i(VVDD))
let power_dc = vdd_current * 1.8
print power_dc

ac dec 100 1 10g
let vout_mag = vm(VCONTROLn)
let gain_db = db(vout_mag)
let dc_gain_db = gain_db[0]
print dc_gain_db

if dc_gain_db > 0
    meas ac ugbw WHEN gain_db=0 CROSS=1
end

quit
.endc

.end
