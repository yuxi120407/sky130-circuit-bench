* Testcase 000776 — Full Analysis (sky130 tt corner)
* SKY130 model header — replaces the ideal level-1 .model cards
* Ships with the demo; the paths point at the local sky130 PDK checkout.
* NOTE: libs.tech/ngspice/all.spice sets ".option scale=1.0u", so every
* instance L/W below is written in microns WITHOUT a "u" suffix.
.param mc_mm_switch=0
.param mc_pr_switch=0
.include /home/idies/workspace/Temporary/xyu1/scratch/skywater-pdk-libs-sky130_fd_pr/models/corners/tt.spice
.include /home/idies/workspace/Temporary/xyu1/scratch/skywater-pdk-libs-sky130_fd_pr/models/r+c/res_typical__cap_typical.spice
.include /home/idies/workspace/Temporary/xyu1/scratch/skywater-pdk-libs-sky130_fd_pr/models/r+c/res_typical__cap_typical__lin.spice
.include /home/idies/workspace/Temporary/xyu1/scratch/skywater-pdk-libs-sky130_fd_pr/models/corners/tt/specialized_cells.spice
.model DIDEAL D   is=1e-14 n=1
.options reltol=1e-3 itl1=500 itl2=100

* Sources
VVDD VDD 0 1.8
VVB1 VB1 0 DC 0.9900000000000001 AC 0.5
VVB2 VB2 0 0.9900000000000001
VVB3 VB3 0 0.54
VVCM_REF VCM_REF 0 0.9

* Circuit
XM2 N2 N11 VDD VDD sky130_fd_pr__pfet_01v8 l=0.5 w=5
XM2 VCTL_P N6 N2 VDD sky130_fd_pr__pfet_01v8 l=0.5 w=5
I1 VDD N0 1u
XM1 N5 VB1 VDD VDD sky130_fd_pr__pfet_01v8 l=0.5 w=5
XM4 VCTL_P VB2 N5 VDD sky130_fd_pr__pfet_01v8 l=0.5 w=5
XM5 N9 N9 GND GND sky130_fd_pr__nfet_01v8 l=0.5 w=5
XM6 VCTL_P N8 N4 GND sky130_fd_pr__nfet_01v8 l=0.5 w=5
XM7 VCTL_P VB3 N7 GND sky130_fd_pr__nfet_01v8 l=0.5 w=5
XM8 N1 VCM_REF N0 VDD sky130_fd_pr__pfet_01v8 l=0.5 w=5
XM4 N4 N10 GND GND sky130_fd_pr__nfet_01v8 l=0.5 w=5
XM3 N7 N1 GND GND sky130_fd_pr__nfet_01v8 l=0.5 w=5
XM11 N9 VCTL_P N0 VDD sky130_fd_pr__pfet_01v8 l=0.5 w=5
XM12 N1 N1 GND GND sky130_fd_pr__nfet_01v8 l=0.5 w=5
C_CP_1 VCTL_P GND 1p
C_CP_2 VCTL_P GND 1p
XM13 N9 VCTL_P N0 VDD sky130_fd_pr__pfet_01v8 l=0.5 w=5

.control
set filetype=ascii

op
let vdd_current = abs(i(VVDD))
let power_dc = vdd_current * 1.8
print power_dc

ac dec 100 1 10g
let vout_mag = vm(VCTL_P)
let gain_db = db(vout_mag)
let dc_gain_db = gain_db[0]
print dc_gain_db

if dc_gain_db > 0
    meas ac ugbw WHEN gain_db=0 CROSS=1
end

quit
.endc

.end
