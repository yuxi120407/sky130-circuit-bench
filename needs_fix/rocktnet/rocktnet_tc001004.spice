* Testcase 001004 — Full Analysis (sky130 tt corner)
* SKY130 model header — replaces the ideal level-1 .model cards
* Ships with the demo; the paths point at the local sky130 PDK checkout.
* NOTE: libs.tech/ngspice/all.spice sets ".option scale=1.0u", so every
* instance L/W below is written in microns WITHOUT a "u" suffix.
.param mc_mm_switch=0
.param mc_pr_switch=0
.include /home/idies/workspace/Temporary/xyu1/scratch/skywater-pdk-libs-sky130_fd_pr/models/corners/tt.spice
.include /home/idies/workspace/Temporary/xyu1/scratch/skywater-pdk-libs-sky130_fd_pr/models/r+c/res_typical__cap_typical.spice
.include /home/idies/workspace/Temporary/xyu1/scratch/skywater-pdk-libs-sky130_fd_pr/models/r+c/res_typical__cap_typical__lin.spice
.include /home/idies/workspace/Temporary/xyu1/scratch/skywater-pdk-libs-sky130_fd_pr/models/corners/tt/specialized_cells.spice
.model DIDEAL D   is=1e-14 n=1
.options reltol=1e-3 itl1=500 itl2=100

* Sources
VVDD VDD 0 1.8
VVBL_MINUS VBL_MINUS 0 0.75
VVBH_PLUS VBH_PLUS 0 0.75
VLABEL_NET_0 LABEL_NET_0 0 DC 0.9 AC 0.5
VLABEL_NET_1 LABEL_NET_1 0 DC 0.9 AC -0.5

* Circuit
XSWT VBL_MINUS GND GND GND sky130_fd_pr__nfet_01v8 l=0.5 w=5
L_L VDD VBL_MINUS 10n
XM2 GND VL_MINUS N2 GND sky130_fd_pr__nfet_01v8 l=0.5 w=5
XM3 GND VL_PLUS N2 GND sky130_fd_pr__nfet_01v8 l=0.5 w=5
XM4 GND VL_MINUS N0 GND sky130_fd_pr__nfet_01v8 l=0.5 w=5
XSWT VBH_PLUS GND GND GND sky130_fd_pr__nfet_01v8 l=0.5 w=5
XM6 N0 LABEL_NET_0 GND GND sky130_fd_pr__nfet_01v8 l=0.5 w=5
XM7 N2 LABEL_NET_1 GND GND sky130_fd_pr__nfet_01v8 l=0.5 w=5
XM8 GND VL_PLUS N0 GND sky130_fd_pr__nfet_01v8 l=0.5 w=5
XSWT VBL_MINUS GND GND GND sky130_fd_pr__nfet_01v8 l=0.5 w=5
C_L VBL_MINUS VBL_MINUS 1p
XSWT VBH_PLUS GND GND GND sky130_fd_pr__nfet_01v8 l=0.5 w=5
L_H VDD VBH_PLUS 10n
C_H VBH_PLUS VBH_PLUS 1p
C_H GND GND 1p
C_L GND GND 1p
L_H GND GND 10n
L_L GND GND 10n

.control
set filetype=ascii

op
let vdd_current = abs(i(VVDD))
let power_dc = vdd_current * 1.8
print power_dc

print all

quit
.endc

.end
