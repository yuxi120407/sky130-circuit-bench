* Testcase 000563 — Full Analysis (sky130 tt corner)
* SKY130 model header — replaces the ideal level-1 .model cards
* Ships with the demo; the paths point at the local sky130 PDK checkout.
* NOTE: libs.tech/ngspice/all.spice sets ".option scale=1.0u", so every
* instance L/W below is written in microns WITHOUT a "u" suffix.
.param mc_mm_switch=0
.param mc_pr_switch=0
.include /home/idies/workspace/Temporary/xyu1/scratch/skywater-pdk-libs-sky130_fd_pr/models/corners/tt.spice
.include /home/idies/workspace/Temporary/xyu1/scratch/skywater-pdk-libs-sky130_fd_pr/models/r+c/res_typical__cap_typical.spice
.include /home/idies/workspace/Temporary/xyu1/scratch/skywater-pdk-libs-sky130_fd_pr/models/r+c/res_typical__cap_typical__lin.spice
.include /home/idies/workspace/Temporary/xyu1/scratch/skywater-pdk-libs-sky130_fd_pr/models/corners/tt/specialized_cells.spice
.model DIDEAL D   is=1e-14 n=1
.options reltol=1e-2 abstol=1e-10 vntol=1e-4 itl1=1000 itl2=200 itl4=100
.options gmin=1e-10 method=gear

* Sources

* Circuit
XQ1 N6 N9 N3 0 sky130_fd_pr__npn_05v5_W1p00L1p00
XQ2 N9 N1 N10 0 sky130_fd_pr__npn_05v5_W1p00L1p00
XQ3 N4 N3 N8 0 sky130_fd_pr__npn_05v5_W1p00L1p00
R1 N0 N8 10k
R2 N2 N3 10k
R3 N7 N9 10k
R4 N4 N5 10k
R5 N0 N10 10k
R6 N1 N3 10k
D1 N7 N6 DIDEAL
C1 N0 N10 1p
C2 N7 GND 1p
D2 N7 N5 DIDEAL
D3 N2 GND DIDEAL

.control
set filetype=ascii

op

let dc_voltage = v(N0)
print dc_voltage
print all

quit
.endc

.end
