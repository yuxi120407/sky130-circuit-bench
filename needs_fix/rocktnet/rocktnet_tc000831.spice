* Testcase 000831 — Full Analysis (sky130 tt corner)
* SKY130 model header — replaces the ideal level-1 .model cards
* Ships with the demo; the paths point at the local sky130 PDK checkout.
* NOTE: libs.tech/ngspice/all.spice sets ".option scale=1.0u", so every
* instance L/W below is written in microns WITHOUT a "u" suffix.
.param mc_mm_switch=0
.param mc_pr_switch=0
.include /home/idies/workspace/Temporary/xyu1/scratch/skywater-pdk-libs-sky130_fd_pr/models/corners/tt.spice
.include /home/idies/workspace/Temporary/xyu1/scratch/skywater-pdk-libs-sky130_fd_pr/models/r+c/res_typical__cap_typical.spice
.include /home/idies/workspace/Temporary/xyu1/scratch/skywater-pdk-libs-sky130_fd_pr/models/r+c/res_typical__cap_typical__lin.spice
.include /home/idies/workspace/Temporary/xyu1/scratch/skywater-pdk-libs-sky130_fd_pr/models/corners/tt/specialized_cells.spice
.model DIDEAL D   is=1e-14 n=1
.options reltol=1e-3 itl1=500 itl2=100

* Sources

* Circuit
L OUTp OUTn 10n
C OUTp OUTn 1p
C1 OUTp N1 1p
C2 OUTp N2 1p
C3 OUTp N3 1p
C3 OUTn N4 1p
C2 OUTn N5 1p
C1 OUTn N6 1p
XM1 N1 PHI1 GND GND sky130_fd_pr__nfet_01v8 l=0.5 w=5
XM6 N2 PHI2 GND GND sky130_fd_pr__nfet_01v8 l=0.5 w=5
XM5 N3 PHI3 GND GND sky130_fd_pr__nfet_01v8 l=0.5 w=5
XM3 N4 PHI3 GND GND sky130_fd_pr__nfet_01v8 l=0.5 w=5
XM2 N5 PHI2 GND GND sky130_fd_pr__nfet_01v8 l=0.5 w=5
XM4 N6 PHI1 GND GND sky130_fd_pr__nfet_01v8 l=0.5 w=5

.control
set filetype=ascii

op
let vdd_current = abs(i(VVDD))
let power_dc = vdd_current * 1.8
print power_dc

ac dec 100 1k 100g
let vout_mag = vm(OUTp)
let gain_db = db(vout_mag)

meas ac max_gain_db MAX gain_db
meas ac bw_3db WHEN gain_db='max_gain_db-3' CROSS=1

print max_gain_db bw_3db

quit
.endc

.end
