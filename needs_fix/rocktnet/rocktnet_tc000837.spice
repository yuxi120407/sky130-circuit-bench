* Testcase 000837 — Full Analysis (sky130 tt corner)
* SKY130 model header — replaces the ideal level-1 .model cards
* Ships with the demo; the paths point at the local sky130 PDK checkout.
* NOTE: libs.tech/ngspice/all.spice sets ".option scale=1.0u", so every
* instance L/W below is written in microns WITHOUT a "u" suffix.
.param mc_mm_switch=0
.param mc_pr_switch=0
.include /home/idies/workspace/Temporary/xyu1/scratch/skywater-pdk-libs-sky130_fd_pr/models/corners/tt.spice
.include /home/idies/workspace/Temporary/xyu1/scratch/skywater-pdk-libs-sky130_fd_pr/models/r+c/res_typical__cap_typical.spice
.include /home/idies/workspace/Temporary/xyu1/scratch/skywater-pdk-libs-sky130_fd_pr/models/r+c/res_typical__cap_typical__lin.spice
.include /home/idies/workspace/Temporary/xyu1/scratch/skywater-pdk-libs-sky130_fd_pr/models/corners/tt/specialized_cells.spice
.model DIDEAL D   is=1e-14 n=1
.options reltol=1e-3 itl1=500 itl2=100

* Sources
VVDD VDD 0 1.8
VVBP VBP 0 DC 0.9900000000000001 AC 0.5
VVCMFB1 VCMFB1 0 0.9
VVCMFB2 VCMFB2 0 0.9
VVBN VBN 0 0.54

* Circuit
XM12 VOn VBP VDD VDD sky130_fd_pr__pfet_01v8 l=0.5 w=5
XM5B TAIL_P VCMFB1 VDD VDD sky130_fd_pr__pfet_01v8 l=0.5 w=5
XM5 TAIL_P VBP VDD VDD sky130_fd_pr__pfet_01v8 l=0.5 w=5
XM13 VOp VBP VDD VDD sky130_fd_pr__pfet_01v8 l=0.5 w=5
XM2 MID_LEFT Vn TAIL_P VDD sky130_fd_pr__pfet_01v8 l=0.5 w=5
XM1 MID_RIGHT Vp TAIL_P VDD sky130_fd_pr__pfet_01v8 l=0.5 w=5
XM8 VO1p VCP MID_LEFT VDD sky130_fd_pr__pfet_01v8 l=0.5 w=5
XM9 VO1n VCP MID_RIGHT VDD sky130_fd_pr__pfet_01v8 l=0.5 w=5
XM10 VOn VO1p TAIL_N_LEFT GND sky130_fd_pr__nfet_01v8 l=0.5 w=5
XM6 VO1p VCN TAIL_N_MID_LEFT GND sky130_fd_pr__nfet_01v8 l=0.5 w=5
XM7 VO1n VCN TAIL_N_MID_RIGHT GND sky130_fd_pr__nfet_01v8 l=0.5 w=5
XM11 VOp VO1n TAIL_N_RIGHT GND sky130_fd_pr__nfet_01v8 l=0.5 w=5
XM14B TAIL_N_LEFT VCMFB2 GND GND sky130_fd_pr__nfet_01v8 l=0.5 w=5
XM14 TAIL_N_LEFT VBN GND GND sky130_fd_pr__nfet_01v8 l=0.5 w=5
XM4 TAIL_N_MID_LEFT VBN GND GND sky130_fd_pr__nfet_01v8 l=0.5 w=5
XM3 TAIL_N_MID_RIGHT VBN GND GND sky130_fd_pr__nfet_01v8 l=0.5 w=5
XM15 TAIL_N_RIGHT VBN GND GND sky130_fd_pr__nfet_01v8 l=0.5 w=5
XM15B TAIL_N_RIGHT VCMFB2 GND GND sky130_fd_pr__nfet_01v8 l=0.5 w=5
CC VOn MID_LEFT 1p
CC VOp MID_RIGHT 1p

.control
set filetype=ascii

op
let vdd_current = abs(i(VVDD))
let power_dc = vdd_current * 1.8
print power_dc

print all

quit
.endc

.end
