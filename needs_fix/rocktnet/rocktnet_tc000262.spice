* Testcase 000262 — Full Analysis (sky130 tt corner)
* SKY130 model header — replaces the ideal level-1 .model cards
* Ships with the demo; the paths point at the local sky130 PDK checkout.
* NOTE: libs.tech/ngspice/all.spice sets ".option scale=1.0u", so every
* instance L/W below is written in microns WITHOUT a "u" suffix.
.param mc_mm_switch=0
.param mc_pr_switch=0
.include /home/idies/workspace/Temporary/xyu1/scratch/skywater-pdk-libs-sky130_fd_pr/models/corners/tt.spice
.include /home/idies/workspace/Temporary/xyu1/scratch/skywater-pdk-libs-sky130_fd_pr/models/r+c/res_typical__cap_typical.spice
.include /home/idies/workspace/Temporary/xyu1/scratch/skywater-pdk-libs-sky130_fd_pr/models/r+c/res_typical__cap_typical__lin.spice
.include /home/idies/workspace/Temporary/xyu1/scratch/skywater-pdk-libs-sky130_fd_pr/models/corners/tt/specialized_cells.spice
.model DIDEAL D   is=1e-14 n=1
.options reltol=1e-3 itl1=500 itl2=100

* Sources

* Circuit
L1 N9 N15 10n
L1 N2 N13 10n
L1 N1 N11 10n
L1 N7 N12 10n
L1 N5 N6 10n
L1 N8 N10 10n
L1 N0 N3 10n
L1 N14 N16 10n
R1 N2 N16 10k
R1 N7 N11 10k
R1 N1 N5 10k
R1 N0 N4 10k
C2 N6 GND 1p
R1 N15 N8 10k
R1 N9 N13 10k
C1 N6 N14 1p
R1 N3 N12 10k
C2 N3 GND 1p
R1 N4 N10 10k
C2 N1 GND 1p
C1 N3 N8 1p
C1 N1 N2 1p
C1 N7 N9 1p
C2 N7 GND 1p
C1 N4 N4 1p
C2 N4 GND 1p

.control
set filetype=ascii

ac dec 100 1 10g
let vout_mag = vm(N6)
let gain_db = db(vout_mag)

meas ac max_gain_db MAX gain_db
meas ac bw_3db WHEN gain_db='max_gain_db-3' CROSS=1

print max_gain_db bw_3db

quit
.endc

.end
