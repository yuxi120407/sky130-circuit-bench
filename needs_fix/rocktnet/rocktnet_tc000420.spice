* Testcase 000420 — Full Analysis (sky130 tt corner)
* SKY130 model header — replaces the ideal level-1 .model cards
* Ships with the demo; the paths point at the local sky130 PDK checkout.
* NOTE: libs.tech/ngspice/all.spice sets ".option scale=1.0u", so every
* instance L/W below is written in microns WITHOUT a "u" suffix.
.param mc_mm_switch=0
.param mc_pr_switch=0
.include /home/idies/workspace/Temporary/xyu1/scratch/skywater-pdk-libs-sky130_fd_pr/models/corners/tt.spice
.include /home/idies/workspace/Temporary/xyu1/scratch/skywater-pdk-libs-sky130_fd_pr/models/r+c/res_typical__cap_typical.spice
.include /home/idies/workspace/Temporary/xyu1/scratch/skywater-pdk-libs-sky130_fd_pr/models/r+c/res_typical__cap_typical__lin.spice
.include /home/idies/workspace/Temporary/xyu1/scratch/skywater-pdk-libs-sky130_fd_pr/models/corners/tt/specialized_cells.spice
.model DIDEAL D   is=1e-14 n=1
.options reltol=1e-3 itl1=500 itl2=100

* Sources
VVBIAS VBIAS 0 0.75

* Circuit
I1 N8 VEE 1u
XQ1 N11 VBIAS N8 0 sky130_fd_pr__npn_05v5_W1p00L1p00
RE N13 VEE 10k
RL1 VO VCC 10k
XQ2 N12 VRF N13 0 sky130_fd_pr__npn_05v5_W1p00L1p00
RL1 N0 VCC 10k
XQ4 N10 N2 N11 0 sky130_fd_pr__npn_05v5_W1p00L1p00
XQ6 VO N7 N12 0 sky130_fd_pr__npn_05v5_W1p00L1p00
RL VO VOB 10k
XQ7 VOB N2 N12 0 sky130_fd_pr__npn_05v5_W1p00L1p00
RL N0 N10 10k
XQ5 N0 VAGC N11 0 sky130_fd_pr__npn_05v5_W1p00L1p00
RE N8 VRF 10k
XQ10 VCC N3 N11 0 sky130_fd_pr__npn_05v5_W1p00L1p00
XQ11 N7 N3 N12 0 sky130_fd_pr__npn_05v5_W1p00L1p00

.control
set filetype=ascii

op
let vdd_current = abs(i(VVDD))
let power_dc = vdd_current * 1.8
let vout_dc = v(VO)
print power_dc vout_dc

quit
.endc

.end
