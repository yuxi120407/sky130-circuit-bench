* Testcase 000631 — Full Analysis (sky130 tt corner)
* SKY130 model header — replaces the ideal level-1 .model cards
* Ships with the demo; the paths point at the local sky130 PDK checkout.
* NOTE: libs.tech/ngspice/all.spice sets ".option scale=1.0u", so every
* instance L/W below is written in microns WITHOUT a "u" suffix.
.param mc_mm_switch=0
.param mc_pr_switch=0
.include /home/idies/workspace/Temporary/xyu1/scratch/skywater-pdk-libs-sky130_fd_pr/models/corners/tt.spice
.include /home/idies/workspace/Temporary/xyu1/scratch/skywater-pdk-libs-sky130_fd_pr/models/r+c/res_typical__cap_typical.spice
.include /home/idies/workspace/Temporary/xyu1/scratch/skywater-pdk-libs-sky130_fd_pr/models/r+c/res_typical__cap_typical__lin.spice
.include /home/idies/workspace/Temporary/xyu1/scratch/skywater-pdk-libs-sky130_fd_pr/models/corners/tt/specialized_cells.spice
.model DIDEAL D   is=1e-14 n=1
.options reltol=1e-3 itl1=500 itl2=100

* Sources
VVDD VDD 0 1.8

* Circuit
D1 GND NET_CATH1 DIDEAL
D2 GND NET_CATH2 DIDEAL
RS NET_S1 GND 10k
RG1 VGBIAS GND 10k
C2 NET_S2 NET_S1 1p
RG2 VDD VGBIAS 10k
RG1 NET_G2 GND 10k
C1 NET_D2 NET_S2 1p
CG NET_G2 GND 1p
COUT NET_S2 VOUT1 1p
CVAR NET_D2 NET_CATH2 1p
RS NET_S2 GND 10k
RG2 VDD NET_G2 10k
CG VGBIAS GND 1p
LVAR VVAR NET_CATH1 10n
COUT NET_S1 VOUT2 1p
CVAR NET_D1 NET_CATH1 1p
LTANK VDD NET_D1 10n
C1 NET_D1 NET_S1 1p
LVAR VVAR NET_CATH2 10n
LTANK VDD NET_D2 10n
XM1 NET_D1 VGBIAS NET_S1 GND sky130_fd_pr__nfet_01v8 l=0.5 w=5
XM2 NET_D2 NET_G2 NET_S2 GND sky130_fd_pr__nfet_01v8 l=0.5 w=5

.control
set filetype=ascii

op
let vdd_current = abs(i(VVDD))
let power_dc = vdd_current * 1.8
print power_dc

ac dec 100 1k 100g
let vout_mag = vm(NET_S1)
let gain_db = db(vout_mag)

meas ac max_gain_db MAX gain_db
meas ac bw_3db WHEN gain_db='max_gain_db-3' CROSS=1

print max_gain_db bw_3db

quit
.endc

.end
