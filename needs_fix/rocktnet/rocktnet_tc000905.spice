* Testcase 000905 — Full Analysis (sky130 tt corner)
* SKY130 model header — replaces the ideal level-1 .model cards
* Ships with the demo; the paths point at the local sky130 PDK checkout.
* NOTE: libs.tech/ngspice/all.spice sets ".option scale=1.0u", so every
* instance L/W below is written in microns WITHOUT a "u" suffix.
.param mc_mm_switch=0
.param mc_pr_switch=0
.include /home/idies/workspace/Temporary/xyu1/scratch/skywater-pdk-libs-sky130_fd_pr/models/corners/tt.spice
.include /home/idies/workspace/Temporary/xyu1/scratch/skywater-pdk-libs-sky130_fd_pr/models/r+c/res_typical__cap_typical.spice
.include /home/idies/workspace/Temporary/xyu1/scratch/skywater-pdk-libs-sky130_fd_pr/models/r+c/res_typical__cap_typical__lin.spice
.include /home/idies/workspace/Temporary/xyu1/scratch/skywater-pdk-libs-sky130_fd_pr/models/corners/tt/specialized_cells.spice
.model DIDEAL D   is=1e-14 n=1
.options reltol=1e-3 itl1=500 itl2=100

* Sources
VVDD VDD 0 1.8

* Circuit
XT3 V_C IREF_N N11 GND sky130_fd_pr__nfet_01v8 l=0.5 w=5
XT11 IF N9 N8 GND sky130_fd_pr__nfet_01v8 l=0.5 w=5
XT6 N3 V_C GND GND sky130_fd_pr__nfet_01v8 l=0.5 w=5
XT8 N9 IREF_N N12 GND sky130_fd_pr__nfet_01v8 l=0.5 w=5
XT5 N3 IREF_P V_PLUS VDD sky130_fd_pr__pfet_01v8 l=0.5 w=5
XT12 N8 IF_ENABLE V_MINUS GND sky130_fd_pr__nfet_01v8 l=0.5 w=5
XT7 N9 V_C GND VDD sky130_fd_pr__pfet_01v8 l=0.5 w=5
XT13 IF IF_ENABLE V_PLUS VDD sky130_fd_pr__pfet_01v8 l=0.5 w=5
XT9 N12 IF_ENABLE V_MINUS GND sky130_fd_pr__nfet_01v8 l=0.5 w=5
XT10 IF N3 V_PLUS VDD sky130_fd_pr__pfet_01v8 l=0.5 w=5
XT1 N13 IF V_PLUS VDD sky130_fd_pr__pfet_01v8 l=0.5 w=5
XT2 V_C IREF_P N13 VDD sky130_fd_pr__pfet_01v8 l=0.5 w=5
XT4 N11 IF V_MINUS GND sky130_fd_pr__nfet_01v8 l=0.5 w=5
C V_C V_MINUS 1p

.control
set filetype=ascii

op
let vdd_current = abs(i(VVDD))
let power_dc = vdd_current * 1.8
print power_dc

print all

quit
.endc

.end
