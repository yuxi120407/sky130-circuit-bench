* Testcase 000351 — Full Analysis (sky130 tt corner)
* SKY130 model header — replaces the ideal level-1 .model cards
* Ships with the demo; the paths point at the local sky130 PDK checkout.
* NOTE: libs.tech/ngspice/all.spice sets ".option scale=1.0u", so every
* instance L/W below is written in microns WITHOUT a "u" suffix.
.param mc_mm_switch=0
.param mc_pr_switch=0
.include /home/idies/workspace/Temporary/xyu1/scratch/skywater-pdk-libs-sky130_fd_pr/models/corners/tt.spice
.include /home/idies/workspace/Temporary/xyu1/scratch/skywater-pdk-libs-sky130_fd_pr/models/r+c/res_typical__cap_typical.spice
.include /home/idies/workspace/Temporary/xyu1/scratch/skywater-pdk-libs-sky130_fd_pr/models/r+c/res_typical__cap_typical__lin.spice
.include /home/idies/workspace/Temporary/xyu1/scratch/skywater-pdk-libs-sky130_fd_pr/models/corners/tt/specialized_cells.spice
.model DIDEAL D   is=1e-14 n=1
.options reltol=1e-3 itl1=500 itl2=100

* Sources
VVDD VDD 0 1.8

* Circuit
XQ1 N_Q1_C LO_P N_M1_D 0 sky130_fd_pr__npn_05v5_W1p00L1p00
XQ2 N_Q2_C LO_N N_M1_D 0 sky130_fd_pr__npn_05v5_W1p00L1p00
XQ9 N_Q9_C LO_N N_M2_D 0 sky130_fd_pr__npn_05v5_W1p00L1p00
XQ3 N_Q3_C LO_P N_M2_D 0 sky130_fd_pr__npn_05v5_W1p00L1p00
XQ11 I_P D_P N_Q1_C 0 sky130_fd_pr__npn_05v5_W1p00L1p00
XQ6 I_N D_N N_Q1_C 0 sky130_fd_pr__npn_05v5_W1p00L1p00
XQ7 I_P Q_P N_Q2_C 0 sky130_fd_pr__npn_05v5_W1p00L1p00
XQ4 I_N Q_N N_Q2_C 0 sky130_fd_pr__npn_05v5_W1p00L1p00
XQ12 Q_P I_P N_Q9_C 0 sky130_fd_pr__npn_05v5_W1p00L1p00
XQ5 Q_N I_N N_Q9_C 0 sky130_fd_pr__npn_05v5_W1p00L1p00
XQ8 Q_P D_P N_Q3_C 0 sky130_fd_pr__npn_05v5_W1p00L1p00
XQ10 Q_N D_N N_Q3_C 0 sky130_fd_pr__npn_05v5_W1p00L1p00
R3 I_P N_TOP 35k
R4 I_N N_TOP 35k
R1 Q_P N_TOP 35k
R2 Q_N N_TOP 35k
R5 N_TOP VDD 24.6k

.control
set filetype=ascii

op
let vdd_current = abs(i(VVDD))
let power_dc = vdd_current * 1.8
print power_dc

print all

quit
.endc

.end
