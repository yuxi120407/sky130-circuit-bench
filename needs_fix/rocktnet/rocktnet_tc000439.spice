* Testcase 000439 — Full Analysis (sky130 tt corner)
* SKY130 model header — replaces the ideal level-1 .model cards
* Ships with the demo; the paths point at the local sky130 PDK checkout.
* NOTE: libs.tech/ngspice/all.spice sets ".option scale=1.0u", so every
* instance L/W below is written in microns WITHOUT a "u" suffix.
.param mc_mm_switch=0
.param mc_pr_switch=0
.include /home/idies/workspace/Temporary/xyu1/scratch/skywater-pdk-libs-sky130_fd_pr/models/corners/tt.spice
.include /home/idies/workspace/Temporary/xyu1/scratch/skywater-pdk-libs-sky130_fd_pr/models/r+c/res_typical__cap_typical.spice
.include /home/idies/workspace/Temporary/xyu1/scratch/skywater-pdk-libs-sky130_fd_pr/models/r+c/res_typical__cap_typical__lin.spice
.include /home/idies/workspace/Temporary/xyu1/scratch/skywater-pdk-libs-sky130_fd_pr/models/corners/tt/specialized_cells.spice
.model DIDEAL D   is=1e-14 n=1
.options reltol=1e-3 itl1=500 itl2=100

* Sources
VINP INP 0 DC 0.9 AC 1 SIN(0.9 0.1 1MEG 0 0)
VINN INN 0 DC 0.9 AC 1 SIN(0.9 0.1 1MEG 0 0)
VLABEL_NET_1 LABEL_NET_1 0 0.9

* Circuit
I1 N0 VEE 1u
I2 N1 VEE 1u
XQ1 N6 INP N0 0 sky130_fd_pr__npn_05v5_W1p00L1p00
XQ3 VCC OUTP N5 0 sky130_fd_pr__npn_05v5_W1p00L1p00
XQ2 OUTN N8 N1 0 sky130_fd_pr__npn_05v5_W1p00L1p00
XQ3 VCC OUTN N7 0 sky130_fd_pr__npn_05v5_W1p00L1p00
XQ1 N8 INN LABEL_NET_1 0 sky130_fd_pr__npn_05v5_W1p00L1p00
XQ2 OUTP N6 N10 0 sky130_fd_pr__npn_05v5_W1p00L1p00
RL2 VCC OUTN 10k
RL1 N7 N8 10k
RL2 VCC OUTP 10k
RL1 N5 N6 10k
RE2 N1 N10 10k
RE1 N0 LABEL_NET_1 10k

.control
set filetype=ascii

op
let vdd_current = abs(i(VVDD))
let power_dc = vdd_current * 1.8
print power_dc

ac dec 100 1 10g
let vout_mag = vm(OUTP)
let gain_db = db(vout_mag)
let dc_gain_db = gain_db[0]
print dc_gain_db

if dc_gain_db > 0
    meas ac ugbw WHEN gain_db=0 CROSS=1
end

quit
.endc

.end
