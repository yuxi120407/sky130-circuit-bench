* Testcase 000240 — Full Analysis (sky130 tt corner)
* SKY130 model header — replaces the ideal level-1 .model cards
* Ships with the demo; the paths point at the local sky130 PDK checkout.
* NOTE: libs.tech/ngspice/all.spice sets ".option scale=1.0u", so every
* instance L/W below is written in microns WITHOUT a "u" suffix.
.param mc_mm_switch=0
.param mc_pr_switch=0
.include /home/idies/workspace/Temporary/xyu1/scratch/skywater-pdk-libs-sky130_fd_pr/models/corners/tt.spice
.include /home/idies/workspace/Temporary/xyu1/scratch/skywater-pdk-libs-sky130_fd_pr/models/r+c/res_typical__cap_typical.spice
.include /home/idies/workspace/Temporary/xyu1/scratch/skywater-pdk-libs-sky130_fd_pr/models/r+c/res_typical__cap_typical__lin.spice
.include /home/idies/workspace/Temporary/xyu1/scratch/skywater-pdk-libs-sky130_fd_pr/models/corners/tt/specialized_cells.spice
.model DIDEAL D   is=1e-14 n=1
.options reltol=1e-3 itl1=500 itl2=100

* Sources
VINP INP 0 DC 0.9 AC 1 SIN(0.9 0.1 1MEG 0 0)
VINN INN 0 DC 0.9 AC 1 SIN(0.9 0.1 1MEG 0 0)
VVCONT VCONT 0 0.9

* Circuit
I1 TAIL_COMMON GND 1u
XM1 ON INP TAIL1 GND sky130_fd_pr__nfet_01v8 l=0.5 w=5
XM2 OP INN TAIL2 GND sky130_fd_pr__nfet_01v8 l=0.5 w=5
XM3 ON OP TAIL1 GND sky130_fd_pr__nfet_01v8 l=0.5 w=5
XM4 OP ON TAIL2 GND sky130_fd_pr__nfet_01v8 l=0.5 w=5
XM5 TAIL1 VCONT TAIL_COMMON GND sky130_fd_pr__nfet_01v8 l=0.5 w=5
XM6 TAIL2 BIAS TAIL_COMMON GND sky130_fd_pr__nfet_01v8 l=0.5 w=5
R1 OP BIAS 10k
R2 ON BIAS 10k

.control
set filetype=ascii

op
let vdd_current = abs(i(VVDD))
let power_dc = vdd_current * 1.8
print power_dc

print all

quit
.endc

.end
