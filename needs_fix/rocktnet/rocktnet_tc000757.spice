* Testcase 000757 — Full Analysis (sky130 tt corner)
* SKY130 model header — replaces the ideal level-1 .model cards
* Ships with the demo; the paths point at the local sky130 PDK checkout.
* NOTE: libs.tech/ngspice/all.spice sets ".option scale=1.0u", so every
* instance L/W below is written in microns WITHOUT a "u" suffix.
.param mc_mm_switch=0
.param mc_pr_switch=0
.include /home/idies/workspace/Temporary/xyu1/scratch/skywater-pdk-libs-sky130_fd_pr/models/corners/tt.spice
.include /home/idies/workspace/Temporary/xyu1/scratch/skywater-pdk-libs-sky130_fd_pr/models/r+c/res_typical__cap_typical.spice
.include /home/idies/workspace/Temporary/xyu1/scratch/skywater-pdk-libs-sky130_fd_pr/models/r+c/res_typical__cap_typical__lin.spice
.include /home/idies/workspace/Temporary/xyu1/scratch/skywater-pdk-libs-sky130_fd_pr/models/corners/tt/specialized_cells.spice
.model DIDEAL D   is=1e-14 n=1
.options reltol=1e-3 itl1=500 itl2=100

* Sources
VVDD VDD 0 1.8
VVIN_PLUS VIN_PLUS 0 DC 0.9 AC 1 SIN(0.9 0.1 1MEG 0 0)
VVB34 VB34 0 0.54
VVIN_MINUS VIN_MINUS 0 DC 0.9 AC 1 SIN(0.9 0.1 1MEG 0 0)
VVB12 VB12 0 0.9900000000000001
VVB56 VB56 0 0.54

* Circuit
XM2 N0 VIN_PLUS N11 VDD sky130_fd_pr__pfet_01v8 l=0.5 w=5
XM13 VOUT N9 GND GND sky130_fd_pr__nfet_01v8 l=0.5 w=5
XM7 N8 N8 VDD VDD sky130_fd_pr__pfet_01v8 l=0.5 w=5
XM4 VB34 VB34 GND GND sky130_fd_pr__nfet_01v8 l=0.5 w=5
XM1 N1 VIN_MINUS N11 VDD sky130_fd_pr__pfet_01v8 l=0.5 w=5
XM14 VOUT N7 VDD VDD sky130_fd_pr__pfet_01v8 l=0.5 w=5
XM12 N9 VB12 VDD VDD sky130_fd_pr__pfet_01v8 l=0.5 w=5
XMB1 N6 N6 VDD VDD sky130_fd_pr__pfet_01v8 l=0.5 w=5
XMB2 N11 N6 VDD VDD sky130_fd_pr__pfet_01v8 l=0.5 w=5
XM10 VB12 VB12 VDD VDD sky130_fd_pr__pfet_01v8 l=0.5 w=5
XM8 N7 N8 VDD VDD sky130_fd_pr__pfet_01v8 l=0.5 w=5
XM9 N2 N7 VDD VDD sky130_fd_pr__pfet_01v8 l=0.5 w=5
XM11 N9 N2 GND GND sky130_fd_pr__nfet_01v8 l=0.5 w=5
XM14 VB56 VB56 VB34 GND sky130_fd_pr__nfet_01v8 l=0.5 w=5
XM4 N0 VB34 GND GND sky130_fd_pr__nfet_01v8 l=0.5 w=5
XM5 N8 VB56 N1 GND sky130_fd_pr__nfet_01v8 l=0.5 w=5
XM10 N2 N2 GND GND sky130_fd_pr__nfet_01v8 l=0.5 w=5
XM3 N1 VB34 GND GND sky130_fd_pr__nfet_01v8 l=0.5 w=5
IBIAS N6 GND 1u
XM6 N7 VB56 N0 GND sky130_fd_pr__nfet_01v8 l=0.5 w=5
IBIAS2 N1 VB56 1u
CM VOUT N7 1p
CL VOUT GND 1p
RO VOUT GND 10k
IBIAS3 VB12 GND 1u

.control
set filetype=ascii

op
let vdd_current = abs(i(VVDD))
let power_dc = vdd_current * 1.8
print power_dc

ac dec 100 1 10g
let vout_mag = vm(VOUT)
let gain_db = db(vout_mag)
let dc_gain_db = gain_db[0]
print dc_gain_db

if dc_gain_db > 0
    meas ac ugbw WHEN gain_db=0 CROSS=1
end

quit
.endc

.end
