* Testcase 000888 — Full Analysis (sky130 tt corner)
* SKY130 model header — replaces the ideal level-1 .model cards
* Ships with the demo; the paths point at the local sky130 PDK checkout.
* NOTE: libs.tech/ngspice/all.spice sets ".option scale=1.0u", so every
* instance L/W below is written in microns WITHOUT a "u" suffix.
.param mc_mm_switch=0
.param mc_pr_switch=0
.include /home/idies/workspace/Temporary/xyu1/scratch/skywater-pdk-libs-sky130_fd_pr/models/corners/tt.spice
.include /home/idies/workspace/Temporary/xyu1/scratch/skywater-pdk-libs-sky130_fd_pr/models/r+c/res_typical__cap_typical.spice
.include /home/idies/workspace/Temporary/xyu1/scratch/skywater-pdk-libs-sky130_fd_pr/models/r+c/res_typical__cap_typical__lin.spice
.include /home/idies/workspace/Temporary/xyu1/scratch/skywater-pdk-libs-sky130_fd_pr/models/corners/tt/specialized_cells.spice
.model DIDEAL D   is=1e-14 n=1
.options reltol=1e-3 itl1=500 itl2=100

* Sources
VLABEL_NET_0 LABEL_NET_0 0 0.9

* Circuit
I3 VCC N5 1u
I4 VCC N0 1u
I5 VCC N6 1u
R2 N1 N5 10k
I6 N8 GND 1u
R4 N6 N7 10k
XQ15 N5 N5 GND 0 sky130_fd_pr__npn_05v5_W1p00L1p00
XQ17 N9 N1 N0 sky130_fd_pr__pnp_05v5_W3p40L3p40
R3 LABEL_NET_0 GND 10k
RC N8 ICTRL 10k
R3 N2 GND 10k
C2 N7 N9 1p
XQ20 N6 N9 GND 0 sky130_fd_pr__npn_05v5_W1p00L1p00
XQ16 N4 ICTRL N0 sky130_fd_pr__pnp_05v5_W3p40L3p40
XQ21 VCC N6 N8 0 sky130_fd_pr__npn_05v5_W1p00L1p00
XQ22 IEXP N8 GND 0 sky130_fd_pr__npn_05v5_W1p00L1p00
XQ19 N9 N4 N2 0 sky130_fd_pr__npn_05v5_W1p00L1p00
XQ18 N4 N4 GND 0 sky130_fd_pr__npn_05v5_W1p00L1p00

.control
set filetype=ascii

op
let vdd_current = abs(i(VVDD))
let power_dc = vdd_current * 1.8
print power_dc

print all

quit
.endc

.end
