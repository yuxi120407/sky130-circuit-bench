* Testcase 000863 — Full Analysis (sky130 tt corner)
* SKY130 model header — replaces the ideal level-1 .model cards
* Ships with the demo; the paths point at the local sky130 PDK checkout.
* NOTE: libs.tech/ngspice/all.spice sets ".option scale=1.0u", so every
* instance L/W below is written in microns WITHOUT a "u" suffix.
.param mc_mm_switch=0
.param mc_pr_switch=0
.include /home/idies/workspace/Temporary/xyu1/scratch/skywater-pdk-libs-sky130_fd_pr/models/corners/tt.spice
.include /home/idies/workspace/Temporary/xyu1/scratch/skywater-pdk-libs-sky130_fd_pr/models/r+c/res_typical__cap_typical.spice
.include /home/idies/workspace/Temporary/xyu1/scratch/skywater-pdk-libs-sky130_fd_pr/models/r+c/res_typical__cap_typical__lin.spice
.include /home/idies/workspace/Temporary/xyu1/scratch/skywater-pdk-libs-sky130_fd_pr/models/corners/tt/specialized_cells.spice
.model DIDEAL D   is=1e-14 n=1
.options reltol=1e-3 itl1=500 itl2=100

* Sources
VVDD VDD 0 1.8

* Circuit
RL1 VDD OUT2 10k
RL2 VDD OUT1 10k
RE1 E_Q5 E_Q3 10k
RE2 E_Q4 E_Q7 10k
I2 E_Q5 GND 1u
I3 E_Q3 GND 1u
I1 E_Q4 GND 1u
I4 E_Q7 GND 1u
XQ8 OUT1 LOQ_P E_Q8_Q12 0 sky130_fd_pr__npn_05v5_W1p00L1p00
XQ12 OUT2 LOQ_N E_Q8_Q12 0 sky130_fd_pr__npn_05v5_W1p00L1p00
XQ2 OUT1 LOQ_N E_Q2_Q6 0 sky130_fd_pr__npn_05v5_W1p00L1p00
XQ6 OUT2 LOQ_P E_Q2_Q6 0 sky130_fd_pr__npn_05v5_W1p00L1p00
XQ11 OUT1 LOI_P E_Q11_Q9 0 sky130_fd_pr__npn_05v5_W1p00L1p00
XQ9 OUT2 LOI_N E_Q11_Q9 0 sky130_fd_pr__npn_05v5_W1p00L1p00
XQ1 OUT1 LOI_N E_Q1_Q10 0 sky130_fd_pr__npn_05v5_W1p00L1p00
XQ10 OUT2 LOI_P E_Q1_Q10 0 sky130_fd_pr__npn_05v5_W1p00L1p00
XQ5 E_Q8_Q12 BBQ_P E_Q5 0 sky130_fd_pr__npn_05v5_W1p00L1p00
XQ3 E_Q2_Q6 BBQ_N E_Q3 0 sky130_fd_pr__npn_05v5_W1p00L1p00
XQ4 E_Q11_Q9 BBI_N E_Q4 0 sky130_fd_pr__npn_05v5_W1p00L1p00
XQ7 E_Q1_Q10 BBI_P E_Q7 0 sky130_fd_pr__npn_05v5_W1p00L1p00

.control
set filetype=ascii

op
let vdd_current = abs(i(VVDD))
let power_dc = vdd_current * 1.8
print power_dc

print all

quit
.endc

.end
