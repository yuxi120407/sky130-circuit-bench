* Testcase 000664 — Full Analysis (sky130 tt corner)
* SKY130 model header — replaces the ideal level-1 .model cards
* Ships with the demo; the paths point at the local sky130 PDK checkout.
* NOTE: libs.tech/ngspice/all.spice sets ".option scale=1.0u", so every
* instance L/W below is written in microns WITHOUT a "u" suffix.
.param mc_mm_switch=0
.param mc_pr_switch=0
.include /home/idies/workspace/Temporary/xyu1/scratch/skywater-pdk-libs-sky130_fd_pr/models/corners/tt.spice
.include /home/idies/workspace/Temporary/xyu1/scratch/skywater-pdk-libs-sky130_fd_pr/models/r+c/res_typical__cap_typical.spice
.include /home/idies/workspace/Temporary/xyu1/scratch/skywater-pdk-libs-sky130_fd_pr/models/r+c/res_typical__cap_typical__lin.spice
.include /home/idies/workspace/Temporary/xyu1/scratch/skywater-pdk-libs-sky130_fd_pr/models/corners/tt/specialized_cells.spice
.model DIDEAL D   is=1e-14 n=1
.options reltol=1e-3 itl1=500 itl2=100

* Sources
VN7 N7 0 0.9
VN5 N5 0 0.9

* Circuit
V1 N7 N2 0
I1 N8 N14 1u
V2 N5 N4 0
I2 N14 GND 1u
V3 N2 GND 0
XQ1 N10 N11 N8 0 sky130_fd_pr__npn_05v5_W1p00L1p00
R1 N0 GND 10k
XQ2 N11 N5 N14 0 sky130_fd_pr__npn_05v5_W1p00L1p00
XQ3 N13 N3 N8 0 sky130_fd_pr__npn_05v5_W1p00L1p00
R2 N1 GND 10k
R3 N11 N12 10k
R4 N0 N10 10k
R5 N1 N9 10k
R6 N3 N6 10k
V4 N4 GND 0
XQ4 GND N1 N6 0 sky130_fd_pr__npn_05v5_W1p00L1p00
XQ5 GND N0 N12 0 sky130_fd_pr__npn_05v5_W1p00L1p00
XQ6 N3 N7 N14 0 sky130_fd_pr__npn_05v5_W1p00L1p00

.control
set filetype=ascii

op
let vdd_current = abs(i(VVDD))
let power_dc = vdd_current * 1.8
print power_dc

print all

quit
.endc

.end
