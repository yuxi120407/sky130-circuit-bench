* Testcase 000719 — Full Analysis (sky130 tt corner)
* SKY130 model header — replaces the ideal level-1 .model cards
* Ships with the demo; the paths point at the local sky130 PDK checkout.
* NOTE: libs.tech/ngspice/all.spice sets ".option scale=1.0u", so every
* instance L/W below is written in microns WITHOUT a "u" suffix.
.param mc_mm_switch=0
.param mc_pr_switch=0
.include /home/idies/workspace/Temporary/xyu1/scratch/skywater-pdk-libs-sky130_fd_pr/models/corners/tt.spice
.include /home/idies/workspace/Temporary/xyu1/scratch/skywater-pdk-libs-sky130_fd_pr/models/r+c/res_typical__cap_typical.spice
.include /home/idies/workspace/Temporary/xyu1/scratch/skywater-pdk-libs-sky130_fd_pr/models/r+c/res_typical__cap_typical__lin.spice
.include /home/idies/workspace/Temporary/xyu1/scratch/skywater-pdk-libs-sky130_fd_pr/models/corners/tt/specialized_cells.spice
.model DIDEAL D   is=1e-14 n=1
.options reltol=1e-2 abstol=1e-10 vntol=1e-4 itl1=1000 itl2=200 itl4=100
.options gmin=1e-10 method=gear

* Sources

* Circuit
XQ1 VCC LO_INp N1 0 sky130_fd_pr__npn_05v5_W1p00L1p00
XQ2 VCC LO_INn N2 0 sky130_fd_pr__npn_05v5_W1p00L1p00
XQ3 VCC N1 N3 0 sky130_fd_pr__npn_05v5_W1p00L1p00
XQ4 VCC N2 N4 0 sky130_fd_pr__npn_05v5_W1p00L1p00
XQ5 N5 N9 N11 0 sky130_fd_pr__npn_05v5_W1p00L1p00
XQ6 N6 N10 N12 0 sky130_fd_pr__npn_05v5_W1p00L1p00
XQ7 OUTn N7 N5 0 sky130_fd_pr__npn_05v5_W1p00L1p00
XQ8 OUTp N8 N5 0 sky130_fd_pr__npn_05v5_W1p00L1p00
XQ9 OUTn N8 N6 0 sky130_fd_pr__npn_05v5_W1p00L1p00
XQ10 OUTp N7 N6 0 sky130_fd_pr__npn_05v5_W1p00L1p00
XQ11 N13 BIAS3 N14 0 sky130_fd_pr__npn_05v5_W1p00L1p00
XQ12 N1 BIAS1 N15 0 sky130_fd_pr__npn_05v5_W1p00L1p00
XQ13 N2 BIAS1 N16 0 sky130_fd_pr__npn_05v5_W1p00L1p00
XQ14 N3 BIAS1 N17 0 sky130_fd_pr__npn_05v5_W1p00L1p00
XQ15 N4 BIAS1 N18 0 sky130_fd_pr__npn_05v5_W1p00L1p00
R1 N1 N2 10k
R2 N7 N8 10k
R3 VCC OUTn 10k
R4 VCC OUTp 10k
R5 N11 N13 10k
R6 N12 N13 10k
R7 N9 BIAS4 10k
R8 N10 BIAS4 10k
R9 N7 BIAS2 10k
R10 N8 BIAS2 10k
R11 N14 GND 10k
R12 N15 GND 10k
R13 N16 GND 10k
R14 N17 GND 10k
R15 N18 GND 10k
C1 N3 N7 1p
C2 N4 N8 1p
C3 RF_INp N9 1p
C4 RF_INn N10 1p
C5 VCC OUTn 1p
C6 VCC OUTp 1p
CBYP1 BIAS1 GND 1p
CBYP2 BIAS2 GND 1p
CBYP3 BIAS3 GND 1p
CBYP4 BIAS4 GND 1p

.control
set filetype=ascii

op

let dc_voltage = v(BIAS1)
print dc_voltage
print all

quit
.endc

.end
