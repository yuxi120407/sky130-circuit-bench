* Testcase 000851 — Full Analysis (sky130 tt corner)
* SKY130 model header — replaces the ideal level-1 .model cards
* Ships with the demo; the paths point at the local sky130 PDK checkout.
* NOTE: libs.tech/ngspice/all.spice sets ".option scale=1.0u", so every
* instance L/W below is written in microns WITHOUT a "u" suffix.
.param mc_mm_switch=0
.param mc_pr_switch=0
.include /home/idies/workspace/Temporary/xyu1/scratch/skywater-pdk-libs-sky130_fd_pr/models/corners/tt.spice
.include /home/idies/workspace/Temporary/xyu1/scratch/skywater-pdk-libs-sky130_fd_pr/models/r+c/res_typical__cap_typical.spice
.include /home/idies/workspace/Temporary/xyu1/scratch/skywater-pdk-libs-sky130_fd_pr/models/r+c/res_typical__cap_typical__lin.spice
.include /home/idies/workspace/Temporary/xyu1/scratch/skywater-pdk-libs-sky130_fd_pr/models/corners/tt/specialized_cells.spice
.model DIDEAL D   is=1e-14 n=1
.options reltol=1e-2 abstol=1e-10 vntol=1e-4 itl1=1000 itl2=200 itl4=100
.options gmin=1e-10 method=gear

* Sources

* Circuit
R1 N2 GND 10k
R2 N2 N4 10k
XQ1 GND N1 QT 0 sky130_fd_pr__npn_05v5_W1p00L1p00
R3 N8 N15 10k
R4 N3 N13 10k
R5 N0 N1 10k
R6 QT QC 10k
R7 VEE N17 10k
R8 N13 N2 10k
R9 N6 VEE 10k
R10 GND N15 10k
R11 QC QT 10k
R12 N0 N15 10k
R13 VEE N5 10k
XQ2 N2 N17 N21 0 sky130_fd_pr__npn_05v5_W1p00L1p00
XQ3 GND N3 N17 0 sky130_fd_pr__npn_05v5_W1p00L1p00
XQ4 N8 N17 N20 0 sky130_fd_pr__npn_05v5_W1p00L1p00
XQ5 N1 N6 N20 0 sky130_fd_pr__npn_05v5_W1p00L1p00
XQ6 N13 N6 N21 0 sky130_fd_pr__npn_05v5_W1p00L1p00
XQ7 GND N8 QC 0 sky130_fd_pr__npn_05v5_W1p00L1p00
XQ8 N10 N5 N11 0 sky130_fd_pr__npn_05v5_W1p00L1p00
R14 N11 VEE 10k
XQ9 N3 DC N22 0 sky130_fd_pr__npn_05v5_W1p00L1p00
XQ10 N15 QT N23 0 sky130_fd_pr__npn_05v5_W1p00L1p00
XQ11 N9 VCS N5 0 sky130_fd_pr__npn_05v5_W1p00L1p00
XQ12 N4 DT N22 0 sky130_fd_pr__npn_05v5_W1p00L1p00
XQ13 N22 DC N9 0 sky130_fd_pr__npn_05v5_W1p00L1p00
XQ14 N6 CC N9 0 sky130_fd_pr__npn_05v5_W1p00L1p00
XQ15 N0 QC N23 0 sky130_fd_pr__npn_05v5_W1p00L1p00
XQ16 N6 N4 GND sky130_fd_pr__pnp_05v5_W3p40L3p40
XQ17 N10 CC N6 sky130_fd_pr__pnp_05v5_W3p40L3p40
XQ18 N10 CC QC sky130_fd_pr__pnp_05v5_W3p40L3p40

.control
set filetype=ascii

op

let dc_voltage = v(N0)
print dc_voltage
print all

quit
.endc

.end
