* Programmable Current Mirror Testbench
.lib "/home/idies/workspace/Temporary/xyu1/scratch/skywater-pdk-libs-sky130_fd_pr/combined_models/sky130.lib.spice" tt
.param L_xm1=0.5
.param L_xm10=0.5
.param L_xm11=0.5
.param L_xm12=0.5
.param L_xm13=0.5
.param L_xm14=0.5
.param L_xm15=0.5
.param L_xm16=0.5
.param L_xm17=0.5
.param L_xm18=0.5
.param L_xm19=0.5
.param L_xm2=0.5
.param L_xm20=0.5
.param L_xm21=0.5
.param L_xm22=0.5
.param L_xm23=0.5
.param L_xm24=0.5
.param L_xm25=0.5
.param L_xm26=0.5
.param L_xm27=0.5
.param L_xm28=0.5
.param L_xm29=0.5
.param L_xm3=0.5
.param L_xm4=0.5
.param L_xm5=0.5
.param L_xm6=0.5
.param L_xm7=0.5
.param L_xm8=0.5
.param L_xm9=0.5

.param W_xm1=5.0 L_xm1=0.5
.param W_xm2=5.0 L_xm2=0.5
.param W_xm3=5.0 L_xm3=0.5
.param W_xm4=5.0 L_xm4=0.5
.param W_xm5=5.0 L_xm5=0.5
.param W_xm6=5.0 L_xm6=0.5
.param W_xm7=5.0 L_xm7=0.5
.param W_xm8=5.0 L_xm8=0.5
.param W_xm9=5.0 L_xm9=0.5
.param W_xm10=5.0 L_xm10=0.5
.param W_xm11=5.0 L_xm11=0.5
.param W_xm12=5.0 L_xm12=0.5
.param W_xm13=5.0 L_xm13=0.5
.param W_xm14=5.0 L_xm14=0.5
.param W_xm15=5.0 L_xm15=0.5
.param W_xm16=5.0 L_xm16=0.5
.param W_xm17=5.0 L_xm17=0.5
.param W_xm18=5.0 L_xm18=0.5
.param W_xm19=5.0 L_xm19=0.5
.param W_xm20=5.0 L_xm20=0.5
.param W_xm21=5.0 L_xm21=0.5
.param W_xm22=5.0 L_xm22=0.5
.param W_xm23=5.0 L_xm23=0.5
.param W_xm24=5.0 L_xm24=0.5
.param W_xm25=5.0 L_xm25=0.5
.param W_xm26=5.0 L_xm26=0.5
.param W_xm27=5.0 L_xm27=0.5
.param W_xm28=5.0 L_xm28=0.5
.param W_xm29=5.0 L_xm29=0.5

XM1 N5 VBD GND GND sky130_fd_pr__nfet_01v8 l={L_xm1} w={W_xm1}
XM2 IIN IIN VDD VDD sky130_fd_pr__pfet_01v8 l={L_xm2} w={W_xm2}
XM3 N10 N10 VDD VDD sky130_fd_pr__pfet_01v8 l={L_xm3} w={W_xm3}
XM4 N18 VBD GND GND sky130_fd_pr__nfet_01v8 l={L_xm4} w={W_xm4}
XM5 N16_MID N16_MID VDD VDD sky130_fd_pr__pfet_01v8 l={L_xm5} w={W_xm5}
XM6 N9 VBD GND GND sky130_fd_pr__nfet_01v8 l={L_xm6} w={W_xm6}
XM7 VBD IIN VDD VDD sky130_fd_pr__pfet_01v8 l={L_xm7} w={W_xm7}
XM8 IIN VBN GND GND sky130_fd_pr__nfet_01v8 l={L_xm8} w={W_xm8}
XM9 N13 VBD GND GND sky130_fd_pr__nfet_01v8 l={L_xm9} w={W_xm9}
XM10 N10 VBD GND GND sky130_fd_pr__nfet_01v8 l={L_xm10} w={W_xm10}
XM11 GND GND GND GND sky130_fd_pr__nfet_01v8 l={L_xm11} w={W_xm11}
XM12 N2 VBD GND GND sky130_fd_pr__nfet_01v8 l={L_xm12} w={W_xm12}
XM13 GND GND GND GND sky130_fd_pr__nfet_01v8 l={L_xm13} w={W_xm13}
XM14 N14 VBD GND GND sky130_fd_pr__nfet_01v8 l={L_xm14} w={W_xm14}
XM15 N20 VBD GND GND sky130_fd_pr__nfet_01v8 l={L_xm15} w={W_xm15}
XM16 N16_MID VBD GND GND sky130_fd_pr__nfet_01v8 l={L_xm16} w={W_xm16}
XM17 N17 VBD GND GND sky130_fd_pr__nfet_01v8 l={L_xm17} w={W_xm17}
XM18 N4 VBD GND GND sky130_fd_pr__nfet_01v8 l={L_xm18} w={W_xm18}
XM19 N3 VBD GND GND sky130_fd_pr__nfet_01v8 l={L_xm19} w={W_xm19}
XM20 N20_OUT N10 VDD VDD sky130_fd_pr__pfet_01v8 l={L_xm20} w={W_xm20}
XM21 N21 VBD GND GND sky130_fd_pr__nfet_01v8 l={L_xm21} w={W_xm21}
XM22 N11 VBD GND GND sky130_fd_pr__nfet_01v8 l={L_xm22} w={W_xm22}
XM23 N23 N16_MID VDD VDD sky130_fd_pr__pfet_01v8 l={L_xm23} w={W_xm23}
XM24 N2 N2 VDD VDD sky130_fd_pr__pfet_01v8 l={L_xm24} w={W_xm24}
XM25 GND GND GND GND sky130_fd_pr__nfet_01v8 l={L_xm25} w={W_xm25}
XM26 N16 N2 VDD VDD sky130_fd_pr__pfet_01v8 l={L_xm26} w={W_xm26}
XM27 N8 VBD GND GND sky130_fd_pr__nfet_01v8 l={L_xm27} w={W_xm27}
XM28 IOUT VBC GND GND sky130_fd_pr__nfet_01v8 l={L_xm28} w={W_xm28}
XM29 N29 VBD GND GND sky130_fd_pr__nfet_01v8 l={L_xm29} w={W_xm29}

* Bias and Supply Sources
VVDD VDD 0 1.8
VVBD VBD 0 0.54
VIIN IIN 0 DC 0.9 AC 1 SIN(0.9 0.1 1MEG 0 0)
VVBN VBN 0 0.54
VVBC VBC 0 0.54

* Output Load Sources (to measure current)
V_N20_OUT N20_OUT 0 DC 0.9
V_N23 N23 0 DC 0.9
V_N16 N16 0 DC 0.9
V_IOUT IOUT 0 DC 0.9

.control
* Transient analysis for DC operating point and power
tran 1n 1u
meas tran I_VDD avg i(VVDD)
let DC_Power = -I_VDD * 1.8
print DC_Power

meas tran I_N20 avg i(V_N20_OUT)
meas tran I_N23 avg i(V_N23)
meas tran I_N16 avg i(V_N16)
let I_out_PMOS = abs(I_N20) + abs(I_N23) + abs(I_N16)
print I_out_PMOS

* AC analysis for transconductance
ac dec 10 1k 1G
let gm_iin_vbd = mag(i(VVBD))
meas ac Gm_IIN find gm_iin_vbd at=1k
print Gm_IIN

quit
.endc
.end
