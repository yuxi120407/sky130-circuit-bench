* Pre-amplifier Testbench
.lib "/home/idies/workspace/Temporary/xyu1/scratch/skywater-pdk-libs-sky130_fd_pr/combined_models/sky130.lib.spice" tt
.param L_xm1=0.5
.param L_xm10=0.5
.param L_xm11=0.5
.param L_xm12=0.5
.param L_xm13=0.5
.param L_xm14=0.5
.param L_xm2=0.5
.param L_xm3=0.5
.param L_xm4=0.5
.param L_xm5=0.5
.param L_xm6=0.5
.param L_xm7=0.5
.param L_xm8=0.5
.param L_xm9=0.5

.param W_xm1=5.0 L_xm1=0.5
.param W_xm2=5.0 L_xm2=0.5
.param W_xm3=5.0 L_xm3=0.5
.param W_xm4=5.0 L_xm4=0.5
.param W_xm5=5.0 L_xm5=0.5
.param W_xm6=5.0 L_xm6=0.5
.param W_xm7=5.0 L_xm7=0.5
.param W_xm8=5.0 L_xm8=0.5
.param W_xm9=5.0 L_xm9=0.5
.param W_xm10=5.0 L_xm10=0.5
.param W_xm11=5.0 L_xm11=0.5
.param W_xm12=5.0 L_xm12=0.5
.param W_xm13=5.0 L_xm13=0.5
.param W_xm14=5.0 L_xm14=0.5

XM1 N8 LABEL_NET_0 GND GND sky130_fd_pr__nfet_01v8 l={L_xm1} w={W_xm1}
XM2 N8 N5 GND GND sky130_fd_pr__nfet_01v8 l={L_xm2} w={W_xm2}
XM3 N7 N4 GND GND sky130_fd_pr__nfet_01v8 l={L_xm3} w={W_xm3}
XM4 N4 N3 N8 GND sky130_fd_pr__nfet_01v8 l={L_xm4} w={W_xm4}
XM5 N7 N0 GND GND sky130_fd_pr__nfet_01v8 l={L_xm5} w={W_xm5}
XM6 N5 N1 N7 GND sky130_fd_pr__nfet_01v8 l={L_xm6} w={W_xm6}
XM7 N5 N0 N2 VDD sky130_fd_pr__pfet_01v8 l={L_xm7} w={W_xm7}
XM8 N6 N5 N6 VDD sky130_fd_pr__pfet_01v8 l={L_xm8} w={W_xm8}
XM9 N2 N1 N5 VDD sky130_fd_pr__pfet_01v8 l={L_xm9} w={W_xm9}
XM10 N4 LABEL_NET_2 N6 VDD sky130_fd_pr__pfet_01v8 l={L_xm10} w={W_xm10}
XM11 N6 N3 N6 VDD sky130_fd_pr__pfet_01v8 l={L_xm11} w={W_xm11}
XM12 N4 N3 VDD VDD sky130_fd_pr__pfet_01v8 l={L_xm12} w={W_xm12}
XM13 N2 N4 N5 VDD sky130_fd_pr__pfet_01v8 l={L_xm13} w={W_xm13}
XM14 N5 N1 VDD VDD sky130_fd_pr__pfet_01v8 l={L_xm14} w={W_xm14}

VVDD VDD 0 1.8
VLABEL_NET_0 LABEL_NET_0 0 0.9
VLABEL_NET_2 LABEL_NET_2 0 0.9
VN0 N0 0 0.9

* Common-mode and offset voltages generated by feedback to ensure stability and zero DC offset
B_cm VCM_raw 0 V='0.9 + 0.5 * tanh((V(N4) + V(N5) - 1.0) * 1000)'
R_cm VCM_raw VCM 1G
C_cm VCM 0 1

B_os N_OS_raw 0 V='0.5 * tanh((V(N4) - V(N5)) * 1000)'
R_os N_OS_raw N_OS 1G
C_os N_OS 0 1

* DC sources for AC and Transient
B_INP_DC N3_DC 0 V='V(VCM) + V(N_OS)/2'
B_INN_DC N1_DC 0 V='V(VCM) - V(N_OS)/2'

* Inputs: N3 (INP), N1 (INN)
VINP N3 N3_DC dc 0 ac 0.5 pulse(-0.05 0.05 1n 10p 10p 10n 20n)
VINN N1 N1_DC dc 0 ac -0.5 pulse(0.05 -0.05 1n 10p 10p 10n 20n)

* Load capacitors
Cload1 N4 0 10f
Cload2 N5 0 10f

* Dependent sources for differential signals
B_diff_in diff_in 0 V=v(N3)-v(N1)
B_diff_out diff_out 0 V=v(N5)-v(N4)

.control
op
let power = -i(VVDD) * 1.8
print power

ac dec 100 1 10G
let gain_mag = mag(v(diff_out))
let gain_db = 20 * log10(gain_mag)
meas ac dc_gain find gain_db at=10
meas ac bandwidth when gain_db='dc_gain - 3' fall=1
print dc_gain bandwidth

tran 10p 5n
meas tran delay trig v(diff_in) val=0 rise=1 targ v(diff_out) val=0 rise=1
print delay

quit
.endc
.end
