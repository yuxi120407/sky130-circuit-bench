* CIRCUIT: Chap21_LTspice/Fig21_9
* YAML: /home/idies/workspace/Storage/xyu1/persistent/ALIGN-public/simple_circuit_5/OpenManus/autosizer_plus/circuits_yaml_generated/Chap21_LTspice__Fig21_9.yaml
* Variables: ['W_M1', 'W_M2', 'R1', 'RS', 'C1']
* Trial values (midpoint): [1.47, 1.47, 1000000000.0, 100000.0, 1e-06]
* Metrics: ['dc_gain_db', 'ugbw', 'power_dc', 'fom']
* Class: mosfet_digital_or_small

* Circuit: Chap21_LTspice/Fig21_9
.lib ${SKY130_PDK} tt

VDD VDD 0 1.8
xm1 Vout Vin 0 0 sky130_fd_pr__nfet_01v8 w=1.47 l=2
xm2 Vout Vout VDD VDD sky130_fd_pr__pfet_01v8 w=1.47 l=2
X_U1 Vbias1 Vhigh Vbias2 Vpcas Vncas Vbias3 Vlow Vbias4 VDD 0 Fig_20_43
R1 Vbias4 Vin 1000000000.0
C1 Vin N001 1e-06
Vs Vs 0 0 AC 1
RS Vs N001 100000.0
.subckt Fig_20_43 Vbias1 Vhigh Vbias2 Vpcas Vncas Vbias3 Vlow Vbias4 VDD GND
  xmsu2 N001 N001 VDD VDD sky130_fd_pr__pfet_01v8 w=10 l=20
  xmsu1 N001 Vbiasn 0 0 sky130_fd_pr__nfet_01v8 w=10 l=2
  xmsu3 N002 N001 Vbiasn 0 sky130_fd_pr__nfet_01v8 w=10 l=1
  xm3 Vbiasn N002 VDD VDD sky130_fd_pr__pfet_01v8 w=30 l=2
  xm4 N002 N002 VDD VDD sky130_fd_pr__pfet_01v8 w=30 l=2
  xm1 Vbiasn Vbiasn 0 0 sky130_fd_pr__nfet_01v8 w=10 l=2
  xm2 N002 Vbiasn N003 0 sky130_fd_pr__nfet_01v8 w=40 l=2
  R1 N003 0 6.5k
  xm5 Vbias2 Vbias2 VDD VDD sky130_fd_pr__pfet_01v8 w=30 l=10
  xm6 Vbias2 Vbiasn 0 0 sky130_fd_pr__nfet_01v8 w=10 l=2
  xm7 N005 Vbias1 VDD VDD sky130_fd_pr__pfet_01v8 w=30 l=2
  xm8 Vbias1 Vbiasn 0 0 sky130_fd_pr__nfet_01v8 w=10 l=2
  xm9 Vbias1 Vbias2 N005 VDD sky130_fd_pr__pfet_01v8 w=30 l=2
  xm10 Vhigh Vbias1 VDD VDD sky130_fd_pr__pfet_01v8 w=30 l=2
  xm11 Vncas Vbias2 Vhigh VDD sky130_fd_pr__pfet_01v8 w=30 l=2
  xm12 Vncas Vncas N009 0 sky130_fd_pr__nfet_01v8 w=10 l=2
  xm13 N009 Vbias3 N010 0 sky130_fd_pr__nfet_01v8 w=10 l=2
  xm14 N010 N009 GND 0 sky130_fd_pr__nfet_01v8 w=10 l=2
  xm15 N006 Vbias1 VDD VDD sky130_fd_pr__pfet_01v8 w=30 l=2
  xm16 Vbias3 Vbias2 N006 VDD sky130_fd_pr__pfet_01v8 w=30 l=2
  xm17 N007 Vbias1 VDD VDD sky130_fd_pr__pfet_01v8 w=30 l=2
  xm18 Vbias4 Vbias2 N007 VDD sky130_fd_pr__pfet_01v8 w=30 l=2
  xm19 N008 N004 VDD VDD sky130_fd_pr__pfet_01v8 w=30 l=2
  xm20 N004 Vbias2 N008 VDD sky130_fd_pr__pfet_01v8 w=30 l=2
  xm21 Vpcas Vpcas N004 VDD sky130_fd_pr__pfet_01v8 w=30 l=2
  xm22 Vbias3 Vbias3 0 0 sky130_fd_pr__nfet_01v8 w=10 l=10
  xm23 Vpcas Vbias3 N011 0 sky130_fd_pr__nfet_01v8 w=10 l=2
  xm24 N011 Vbias4 0 0 sky130_fd_pr__nfet_01v8 w=10 l=2
  xm25 Vbias4 Vbias3 Vlow 0 sky130_fd_pr__nfet_01v8 w=10 l=2
  xm26 Vlow Vbias4 0 0 sky130_fd_pr__nfet_01v8 w=10 l=2
.ends Fig_20_43

.control
op
let vdd_current = abs(i(VDD))
let power_dc = vdd_current * v(VDD)
print power_dc

ac dec 100 1 10g
let vout_mag = vm(vout)
let gain_db = db(vout_mag)
let dc_gain_db = gain_db[0]
print dc_gain_db

if dc_gain_db > 0
    meas ac ugbw WHEN gain_db=0 CROSS=1
end

let phase = vp(vout)
let dc_phase = phase[0]

quit
.endc

.end
