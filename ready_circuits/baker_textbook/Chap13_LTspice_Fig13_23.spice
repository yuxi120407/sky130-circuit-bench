* Circuit: Chap13_LTspice/Fig13_23
.lib ${SKY130_PDK} tt

xm1 N004 N002 0 0 sky130_fd_pr__nfet_01v8 w=1.47 l=0.15
VDD VDD 0 1.8
xm2 N004 N002 VDD VDD sky130_fd_pr__pfet_01v8 w=1.47 l=0.15
xm5 N003 N004 0 0 sky130_fd_pr__nfet_01v8 w=1.47 l=0.15
xm6 N003 N004 VDD VDD sky130_fd_pr__pfet_01v8 w=1.47 l=0.15
xm7 D clock_b N002 0 sky130_fd_pr__nfet_01v8 w=1.47 l=0.15
VD D 0 DC 0.9 AC 1
Vclock_b clock_b 0 PULSE 1 0 0 10p 10p 1.1n 2.2n
Vclock clock 0 PULSE 0 1 0 10p 10p 1.1n 2.2n
xm3 N002 clock D VDD sky130_fd_pr__pfet_01v8 w=1.47 l=0.15
xm4 N002 clock N003 0 sky130_fd_pr__nfet_01v8 w=1.47 l=0.15
xm8 N003 clock_b N002 VDD sky130_fd_pr__pfet_01v8 w=1.47 l=0.15
xm9 Q N001 0 0 sky130_fd_pr__nfet_01v8 w=1.47 l=0.15
xm10 Q N001 VDD VDD sky130_fd_pr__pfet_01v8 w=1.47 l=0.15
xm11 Q_bar Q 0 0 sky130_fd_pr__nfet_01v8 w=1.47 l=0.15
xm12 Q_bar Q VDD VDD sky130_fd_pr__pfet_01v8 w=1.47 l=0.15
xm13 N004 clock N001 0 sky130_fd_pr__nfet_01v8 w=1.47 l=0.15
xm14 N001 clock_b N004 VDD sky130_fd_pr__pfet_01v8 w=1.47 l=0.15
xm15 N001 clock_b Q_bar 0 sky130_fd_pr__nfet_01v8 w=1.47 l=0.15
xm16 Q_bar clock N001 VDD sky130_fd_pr__pfet_01v8 w=1.47 l=0.15

.control
set filetype=ascii

op
let power_dc = abs(i(VDD)) * 1.8
print power_dc

ac dec 100 1 10g
let gain_N003 = db(vm(N003))
let gain_N002 = db(vm(N002))
let gain_N004 = db(vm(N004))
let gain_Q_bar = db(vm(Q_bar))
let gain_N001 = db(vm(N001))
meas ac max_gain_N003 MAX gain_N003
meas ac max_gain_N002 MAX gain_N002
meas ac max_gain_N004 MAX gain_N004
meas ac max_gain_Q_bar MAX gain_Q_bar
meas ac max_gain_N001 MAX gain_N001

* Use first probe node for standard metrics
let gain_db = db(vm(N003))
meas ac dc_gain_db FIND gain_db AT=1
meas ac ugbw WHEN gain_db=0 CROSS=1
let vout_dc = v(N003)

print dc_gain_db ugbw vout_dc gain_N003 gain_N002 gain_N004 gain_Q_bar gain_N001

quit
.endc

.end
