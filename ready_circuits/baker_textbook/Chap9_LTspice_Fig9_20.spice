* Circuit: Chap9_LTspice/Fig9_20
.lib ${SKY130_PDK} tt

xm2 vd24 N001 vs12 0 sky130_fd_pr__nfet_01v8 w=1 l=0.15
VDD VDD 0 1.8
Ibias vs12 0 40µ
xm1 vd13 vg1 vs12 0 sky130_fd_pr__nfet_01v8 w=1.47 l=2
xm4 vd24 0 VDD VDD sky130_fd_pr__pfet_01v8 w=1.47 l=2
xm3 vd13 vd13 VDD VDD sky130_fd_pr__pfet_01v8 w=1.47 l=2
VG1 vg1 0 DC 0.9 AC 1
VG2 N001 0 0.9

.control
set filetype=ascii

op
let power_dc = abs(i(VDD)) * 1.8
print power_dc

ac dec 100 1 10g
let gain_vs12 = db(vm(vs12))
let gain_vd13 = db(vm(vd13))
let gain_vd24 = db(vm(vd24))
meas ac max_gain_vs12 MAX gain_vs12
meas ac max_gain_vd13 MAX gain_vd13
meas ac max_gain_vd24 MAX gain_vd24

* Use first probe node for standard metrics
let gain_db = db(vm(vs12))
meas ac dc_gain_db FIND gain_db AT=1
meas ac ugbw WHEN gain_db=0 CROSS=1
let vout_dc = v(vs12)

print dc_gain_db ugbw vout_dc gain_vs12 gain_vd13 gain_vd24

quit
.endc

.end
