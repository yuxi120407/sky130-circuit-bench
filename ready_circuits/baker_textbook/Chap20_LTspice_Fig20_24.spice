* Circuit: Chap20_LTspice/Fig20_24
.lib ${SKY130_PDK} tt

VDD VDD 0 PULSE(0 1 50n 10p 10p 100u)
xmsu2 N002 N002 VDD VDD sky130_fd_pr__pfet_01v8 w=1 l=0.15
xmsu1 N002 Vbiasn 0 0 sky130_fd_pr__nfet_01v8 w=1 l=0.15
xmsu3 Vbiasp N002 Vbiasn 0 sky130_fd_pr__nfet_01v8 w=1 l=0.15
xm3 Vbiasn Vbiasp VDD VDD sky130_fd_pr__pfet_01v8 w=1.47 l=0.15
xm4 N003 Vbiasp VDD VDD sky130_fd_pr__pfet_01v8 w=1.47 l=0.15
xm1 Vbiasn Vbiasn 0 0 sky130_fd_pr__nfet_01v8 w=1 l=0.15
xm2 N003 N003 N004 0 sky130_fd_pr__nfet_01v8 w=1.47 l=0.15
R1 N004 0 5500.0
xma4 Vbiasp N001 VDD VDD sky130_fd_pr__pfet_01v8 w=1.47 l=0.15
xma3 N001 N001 VDD VDD sky130_fd_pr__pfet_01v8 w=1.47 l=0.15
xm5 N001 N003 0 0 sky130_fd_pr__nfet_01v8 w=1 l=0.15
xm6 Vbiasp Vbiasn 0 0 sky130_fd_pr__nfet_01v8 w=1 l=0.15
xm7 VDD 0 VDD VDD sky130_fd_pr__pfet_01v8 w=1.47 l=5
xm8 0 0 0 0 sky130_fd_pr__nfet_01v8 w=1.47 l=5

.control
set filetype=ascii

op
let power_dc = abs(i(VDD)) * 1.8
let vout_dc = v(Vbiasp)
print power_dc vout_dc

quit
.endc

.end
