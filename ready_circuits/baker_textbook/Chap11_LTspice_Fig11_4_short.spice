* CIRCUIT: Chap11_LTspice/Fig11_4_short
* YAML: /home/idies/workspace/Storage/xyu1/persistent/ALIGN-public/simple_circuit_5/OpenManus/autosizer_plus/circuits_yaml_generated/Chap11_LTspice__Fig11_4_short.yaml
* Variables: ['W_M1', 'W_M2']
* Trial values (midpoint): [1.47, 1.47]
* Metrics: ['dc_gain_db', 'power_dc', 'fom']
* Class: mosfet_digital_or_small

* Circuit: Chap11_LTspice/Fig11_4_short
.lib ${SKY130_PDK} tt

xm1 Vout Vin 0 0 sky130_fd_pr__nfet_01v8 w=1.47 l=0.15
Vin Vin 0 0
VDD VDD 0 1.8
xm2 Vout Vin VDD VDD sky130_fd_pr__pfet_01v8 w=1.47 l=0.15

.control
dc VIN 0 1.8 0.018

let vout_deriv = deriv(v(vout))
let gain_linear = abs(vout_deriv)
let gain_db = db(gain_linear)
meas dc dc_gain_db MAX gain_db

let vdd_current = abs(i(VDD))
let power_dc = mean(vdd_current) * 1.8
print dc_gain_db power_dc

quit
.endc

.end
