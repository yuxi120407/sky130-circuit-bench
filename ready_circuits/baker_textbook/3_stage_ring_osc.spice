* 3-Stage Ring Oscillator
.lib ${SKY130_PDK} tt

XMP0 N1 N0 VDD VDD sky130_fd_pr__pfet_01v8 l=0.15 w=2.0
XMN0 N1 N0 0 0 sky130_fd_pr__nfet_01v8 l=0.15 w=2.0

XMP1 N2 N1 VDD VDD sky130_fd_pr__pfet_01v8 l=0.15 w=2.0
XMN1 N2 N1 0 0 sky130_fd_pr__nfet_01v8 l=0.15 w=2.0

XMP2 N0 N2 VDD VDD sky130_fd_pr__pfet_01v8 l=0.15 w=2.0
XMN2 N0 N2 0 0 sky130_fd_pr__nfet_01v8 l=0.15 w=2.0

CL N0 0 10f
VDD VDD 0 DC 1.8
.ic v(N0)=1.8

.control
tran 1p 50n

meas tran v_first WHEN v(N0)=0.9 RISE=1
meas tran v_second WHEN v(N0)=0.9 RISE=2
let period = v_second - v_first
print period

let i_avg = mean(-i(VDD))
print i_avg

let power_avg = mean(v(VDD) * abs(i(VDD)))
print power_avg

quit
.endc

.end
