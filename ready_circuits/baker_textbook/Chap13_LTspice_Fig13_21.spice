* Circuit: Chap13_LTspice/Fig13_21
.lib ${SKY130_PDK} tt

xm1 Q_bar N001 0 0 sky130_fd_pr__nfet_01v8 w=1.47 l=0.15
VDD VDD 0 1.8
xm2 Q_bar N001 VDD VDD sky130_fd_pr__pfet_01v8 w=1.47 l=0.15
xm5 Q Q_bar 0 0 sky130_fd_pr__nfet_01v8 w=1.47 l=0.15
xm6 Q Q_bar VDD VDD sky130_fd_pr__pfet_01v8 w=1.47 l=0.15
xm7 D clock N001 0 sky130_fd_pr__nfet_01v8 w=1.47 l=0.15
VD D 0 PULSE 0 1 500p 10p 10p 700p 1.9n
Vclock clock 0 PULSE 0 1 0 10p 10p 1n 2n
xm3 N001 clock_b D VDD sky130_fd_pr__pfet_01v8 w=1.47 l=0.15
xm4 N001 clock_b Q 0 sky130_fd_pr__nfet_01v8 w=1.47 l=0.15
xm8 Q clock N001 VDD sky130_fd_pr__pfet_01v8 w=1.47 l=0.15
Vclock1 clock_b 0 DC 0.9 AC 1

.control
set filetype=ascii

op
let power_dc = abs(i(VDD)) * 1.8
print power_dc

ac dec 100 1 10g
let gain_Q_bar = db(vm(Q_bar))
let gain_N001 = db(vm(N001))
let gain_Q = db(vm(Q))
meas ac max_gain_Q_bar MAX gain_Q_bar
meas ac max_gain_N001 MAX gain_N001
meas ac max_gain_Q MAX gain_Q

* Use first probe node for standard metrics
let gain_db = db(vm(Q_bar))
meas ac dc_gain_db FIND gain_db AT=1
meas ac ugbw WHEN gain_db=0 CROSS=1
let vout_dc = v(Q_bar)

print dc_gain_db ugbw vout_dc gain_Q_bar gain_N001 gain_Q

quit
.endc

.end
