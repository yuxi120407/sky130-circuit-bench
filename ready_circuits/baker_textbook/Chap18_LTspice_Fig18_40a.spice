* CIRCUIT: Chap18_LTspice_Fig18_40a
* YAML: /home/idies/workspace/Storage/xyu1/persistent/ALIGN-public/simple_circuit_5/OpenManus/autosizer_plus/circuits_yaml_generated/Chap18_LTspice__Fig18_40a.yaml
* Variables: ['W_nfet_g0', 'Cload']
* Trial values (midpoint): [1.47, 1e-14]
* Metrics: ['avg_power', 'vout_swing', 'rise_time', 'fall_time', 'fom']
* Class: mosfet_digital_or_small
* FOM: 5.062595238499263e-11
* FIXED: node rename {'vout': 'out'}

* Circuit: Chap18_LTspice/Fig18_40a
.lib ${SKY130_PDK} tt

xmpd out in 0 0 sky130_fd_pr__nfet_01v8 w=1.47 l=0.15
Vin in 0 PULSE(1.8 0 0 10p 10p 5ns 10ns)
VDD VDD 0 1.8
xmc out boot out 0 sky130_fd_pr__nfet_01v8 w=1.47 l=0.5
xmpu VDD boot out 0 sky130_fd_pr__nfet_01v8 w=1.47 l=0.2
xmd VDD VDD boot 0 sky130_fd_pr__nfet_01v8 w=1.47 l=0.15
Cload out 0 1e-14

.control
tran 1p 100n

let power = v(VDD) * abs(i(VDD))
let avg_power = mean(power)
print avg_power

meas tran vout_max MAX v(out)
meas tran vout_min MIN v(out)
let vout_swing = vout_max - vout_min
print vout_swing

meas tran rise_time TRIG v(out) VAL='0.1*vout_max' RISE=1 TARG v(out) VAL='0.9*vout_max' RISE=1
meas tran fall_time TRIG v(out) VAL='0.9*vout_max' FALL=1 TARG v(out) VAL='0.1*vout_max' FALL=1
print rise_time fall_time

quit
.endc

.end
