* Circuit: Chap13_LTspice/Fig13_34
.lib ${SKY130_PDK} tt

xm1 B A 0 0 sky130_fd_pr__nfet_01v8 w=1.47 l=0.15
VDD VDD 0 1.8
xm2 B A VDD VDD sky130_fd_pr__pfet_01v8 w=1.47 l=0.15
xm5 N001 B 0 0 sky130_fd_pr__nfet_01v8 w=1.47 l=0.15
xm6 N001 B VDD VDD sky130_fd_pr__pfet_01v8 w=1.47 l=0.15
xm7 D VDD A 0 sky130_fd_pr__nfet_01v8 w=1.47 l=0.15
VD D 0 DC 0.9 AC 1
xm3 A 0 D VDD sky130_fd_pr__pfet_01v8 w=1.47 l=0.15
xm4 A 0 N001 0 sky130_fd_pr__nfet_01v8 w=1.47 l=0.15
xm8 N001 VDD A VDD sky130_fd_pr__pfet_01v8 w=1.47 l=0.15
xm9 N001 0 N002 0 sky130_fd_pr__nfet_01v8 w=1.47 l=0.15
xm10 N002 VDD N001 VDD sky130_fd_pr__pfet_01v8 w=1.47 l=0.15

.control
set filetype=ascii

op
let power_dc = abs(i(VDD)) * 1.8
print power_dc

ac dec 100 1 10g
let gain_N002 = db(vm(N002))
let gain_B = db(vm(B))
let gain_A = db(vm(A))
let gain_N001 = db(vm(N001))
meas ac max_gain_N002 MAX gain_N002
meas ac max_gain_B MAX gain_B
meas ac max_gain_A MAX gain_A
meas ac max_gain_N001 MAX gain_N001

* Use first probe node for standard metrics
let gain_db = db(vm(N002))
meas ac dc_gain_db FIND gain_db AT=1
meas ac ugbw WHEN gain_db=0 CROSS=1
let vout_dc = v(N002)

print dc_gain_db ugbw vout_dc gain_N002 gain_B gain_A gain_N001

quit
.endc

.end
