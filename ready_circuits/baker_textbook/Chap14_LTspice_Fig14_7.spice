* Circuit: Chap14_LTspice/Fig14_7
.lib ${SKY130_PDK} tt

xm1 Q_bar stor 0 0 sky130_fd_pr__nfet_01v8 w=1.47 l=0.15
VDD VDD 0 1.8
xm2 Q_bar stor VDD VDD sky130_fd_pr__pfet_01v8 w=1.47 l=0.15
xm3 Q Q_bar 0 0 sky130_fd_pr__nfet_01v8 w=1.47 l=0.15
xm4 Q Q_bar VDD VDD sky130_fd_pr__pfet_01v8 w=1.47 l=0.15
xm5 0 0 stor 0 sky130_fd_pr__nfet_01v8 w=1.47 l=0.15

.control
set filetype=ascii

op
let vdd_current = abs(i(VDD))
let power_dc = vdd_current * 1.8
let vnode_Q = v(Q)
let vnode_Q_bar = v(Q_bar)
let vnode_stor = v(stor)
let vout_dc = vnode_Q
print power_dc vout_dc vnode_Q vnode_Q_bar vnode_stor

let vout_dc = v(Q_bar)
print vout_dc
let vout_dc = v(Q)
print vout_dc
quit
.endc

.end
