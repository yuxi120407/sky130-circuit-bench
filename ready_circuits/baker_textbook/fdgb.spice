"* FDGB Simulation (Fully Differential Gain Boosting)
.lib ${SKY130_PDK} tt

.subckt FDGB GNDA VDDA VINN VINP VOUTN VOUTP
* BIAS GENERATION
xm_bias_p0 VBIAS_P0 VBIAS_P0 VDDA VDDA sky130_fd_pr__pfet_01v8 l=1.5 w=1.0 m=4
xm_bias_p1 VBIAS_P1 VBIAS_P0 VDDA VDDA sky130_fd_pr__pfet_01v8 l=1.5 w=1.0 m=4
xm_bias_p1_load VBIAS_P1 VBIAS_P1 GNDA GNDA sky130_fd_pr__nfet_01v8 l=1.5 w=1.5 m=4
xm_bias_n0 VBIAS_N0 VBIAS_N0 GNDA GNDA sky130_fd_pr__nfet_01v8 l=1.5 w=1.5 m=4
xm_bias_n0_src VBIAS_N0 VBIAS_P0 VDDA VDDA sky130_fd_pr__pfet_01v8 l=1.5 w=1.0 m=4
xm_bias_n1 VBIAS_N1 VBIAS_N1 GNDA GNDA sky130_fd_pr__nfet_01v8 l=1.5 w=1.5 m=4
xm_bias_n1_src VBIAS_N1 VBIAS_P0 VDDA VDDA sky130_fd_pr__pfet_01v8 l=1.5 w=1.0 m=4
I0 VBIAS_P0 GNDA 10e-6

* MAIN AMPLIFIER - NMOS Input Differential Pair
xm0 NET_DM_N VINN TAIL GNDA sky130_fd_pr__nfet_01v8 l=1.5 w=1.5 m=4
xm3 NET_DM_P VINP TAIL GNDA sky130_fd_pr__nfet_01v8 l=1.5 w=1.5 m=4
xm4 TAIL VBIAS_N0 GNDA GNDA sky130_fd_pr__nfet_01v8 l=1.5 w=1.5 m=4

* NMOS CASCODE (gain boosted by aux amp 2)
xm7 VOUTP NET_AUX2_P NET_DM_N GNDA sky130_fd_pr__nfet_01v8 l=1.5 w=1.5 m=4
xm8 VOUTN NET_AUX2_N NET_DM_P GNDA sky130_fd_pr__nfet_01v8 l=1.5 w=1.5 m=4

* PMOS CASCODE (gain boosted by aux amp 1)
xm5 VOUTP NET_AUX1_P NET_CS_P VDDA sky130_fd_pr__pfet_01v8 l=1.5 w=1.5 m=4
xm6 VOUTN NET_AUX1_N NET_CS_N VDDA sky130_fd_pr__pfet_01v8 l=1.5 w=1.5 m=4

* PMOS CURRENT SOURCES
xm1 NET_CS_N VBIAS_P0 VDDA VDDA sky130_fd_pr__pfet_01v8 l=1.5 w=1.5 m=4
xm2 NET_CS_P VBIAS_P0 VDDA VDDA sky130_fd_pr__pfet_01v8 l=1.5 w=1.5 m=4

* AUXILIARY AMP 1 (boosts PMOS cascode)
xm12 NET_AUX1_N NET_CS_N TAIL_AUX GNDA sky130_fd_pr__nfet_01v8 l=1.5 w=1.5 m=2
xm13 NET_AUX1_P NET_CS_P TAIL_AUX GNDA sky130_fd_pr__nfet_01v8 l=1.5 w=1.5 m=2
xm11 TAIL_AUX VBIAS_N1 GNDA GNDA sky130_fd_pr__nfet_01v8 l=1.5 w=1.5 m=2
xm9 NET_AUX1_N VBIAS_P1 VDDA VDDA sky130_fd_pr__pfet_01v8 l=1.5 w=1.5 m=2
xm10 NET_AUX1_P VBIAS_P1 VDDA VDDA sky130_fd_pr__pfet_01v8 l=1.5 w=1.5 m=2

* AUXILIARY AMP 2 (boosts NMOS cascode)
xm17 NET_AUX2_P NET_DM_N TAIL_AUX GNDA sky130_fd_pr__nfet_01v8 l=1.5 w=1.5 m=2
xm18 NET_AUX2_N NET_DM_P TAIL_AUX GNDA sky130_fd_pr__nfet_01v8 l=1.5 w=1.5 m=2
xm16 TAIL_AUX VBIAS_N1 GNDA GNDA sky130_fd_pr__nfet_01v8 l=1.5 w=1.5 m=2
xm14 NET_AUX2_P VBIAS_P1 VDDA VDDA sky130_fd_pr__pfet_01v8 l=1.5 w=1.5 m=2
xm15 NET_AUX2_N VBIAS_P1 VDDA VDDA sky130_fd_pr__pfet_01v8 l=1.5 w=1.5 m=2
.ends FDGB

VDD VDD 0 DC 1.8
VSS VSS 0 DC 0
VINP VINP 0 DC 0.9 AC 0.5
VINN VINN 0 DC 0.9 AC -0.5

XDUT VSS VDD VINN VINP VOUTN VOUTP FDGB

CLP VOUTP 0 15e-9
CLN VOUTN 0 15e-9
RLP VOUTP 0 25e3
RLN VOUTN 0 25e3

* Differential output measurement
E_DIFF VOUT_DIFF 0 VOL='V(VOUTN)-V(VOUTP)'

.control
op
let vdd_current = abs(i(VDD))
let power_dc = vdd_current * 1.8
print power_dc

ac dec 100 1 10g
let gain_db = vdb(VOUT_DIFF)
let dc_gain_db = gain_db[0]
print dc_gain_db

if dc_gain_db > 0
    meas ac ugbw WHEN gain_db=0 CROSS=1
end
quit
.endc
.end
