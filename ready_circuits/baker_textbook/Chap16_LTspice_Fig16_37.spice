* Circuit: Chap16_LTspice/Fig16_37
.lib ${SKY130_PDK} tt

xm1 N003 Inp 0 0 sky130_fd_pr__nfet_01v8 w=1.47 l=0.15
VDD VDD 0 1.8
xm2 Outm Outp VDD VDD sky130_fd_pr__pfet_01v8 w=1.47 l=0.15
xm3 Outp Outm VDD VDD sky130_fd_pr__pfet_01v8 w=1.47 l=0.15
xm5 N002 Outm N004 0 sky130_fd_pr__nfet_01v8 w=1.47 l=0.15
xm6 N001 Outp N003 0 sky130_fd_pr__nfet_01v8 w=1.47 l=0.15
Vclock clock 0 PULSE(0 1.8 0 10p 10p 5n 10n)
xm4 Outm clock VDD VDD sky130_fd_pr__pfet_01v8 w=1.47 l=0.15
xm7 Outp clock VDD VDD sky130_fd_pr__pfet_01v8 w=1.47 l=0.15
xm8 Outm clock N001 0 sky130_fd_pr__nfet_01v8 w=1.47 l=0.15
xm9 Outp clock N002 0 sky130_fd_pr__nfet_01v8 w=1.47 l=0.15
xm10 N004 Inm 0 0 sky130_fd_pr__nfet_01v8 w=1.47 l=0.15
X_U1 Outp Q Qi VDD 0 NAND_2
X_U2 Qi Outm Q VDD 0 NAND_2
xm11 Inp VDD VDD VDD sky130_fd_pr__pfet_01v8 w=1.47 l=0.5
xm12 Inp VDD 0 0 sky130_fd_pr__nfet_01v8 w=1.47 l=0.5
xm13 Inm 0 VDD VDD sky130_fd_pr__pfet_01v8 w=1.47 l=0.5
xm14 Inm 0 0 0 sky130_fd_pr__nfet_01v8 w=1.47 l=0.5
.subckt NAND_2 A B Out VDD GND
  xm3 out B VDD VDD sky130_fd_pr__pfet_01v8 w=1 l=0.15
  xm8 out A VDD VDD sky130_fd_pr__pfet_01v8 w=1 l=0.15
  xm11 N001 B GND 0 sky130_fd_pr__nfet_01v8 w=0.5 l=0.15
  xm12 out A N001 0 sky130_fd_pr__nfet_01v8 w=0.5 l=0.15
.ends NAND_2

.control
tran 1p 100n

let power = v(VDD) * abs(i(VDD))
let avg_power = mean(power)
print avg_power

meas tran vout_max MAX v(out)
meas tran vout_min MIN v(out)
let vout_swing = vout_max - vout_min
print vout_swing

meas tran rise_time TRIG v(out) VAL='0.1*vout_max' RISE=1 TARG v(out) VAL='0.9*vout_max' RISE=1
meas tran fall_time TRIG v(out) VAL='0.9*vout_max' FALL=1 TARG v(out) VAL='0.1*vout_max' FALL=1
print rise_time fall_time

quit
.endc

.end
