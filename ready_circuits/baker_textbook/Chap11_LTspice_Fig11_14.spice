* Circuit: Chap11_LTspice/Fig11_14
.lib ${SKY130_PDK} tt

xm1 N001 Osc 0 0 sky130_fd_pr__nfet_01v8 w=1.47 l=0.15
VDD VDD 0 1.8
xm2 N001 Osc VDD VDD sky130_fd_pr__pfet_01v8 w=1.47 l=0.15
xm3 N002 N001 0 0 sky130_fd_pr__nfet_01v8 w=1.47 l=0.15
xm4 N002 N001 VDD VDD sky130_fd_pr__pfet_01v8 w=1.47 l=0.15
xm5 N003 N002 0 0 sky130_fd_pr__nfet_01v8 w=1.47 l=0.15
xm6 N003 N002 VDD VDD sky130_fd_pr__pfet_01v8 w=1.47 l=0.15
xm7 N004 N003 0 0 sky130_fd_pr__nfet_01v8 w=1.47 l=0.15
xm8 N004 N003 VDD VDD sky130_fd_pr__pfet_01v8 w=1.47 l=0.15
xm9 N005 N004 0 0 sky130_fd_pr__nfet_01v8 w=1.47 l=0.15
xm10 N005 N004 VDD VDD sky130_fd_pr__pfet_01v8 w=1.47 l=0.15
xm11 N006 N005 0 0 sky130_fd_pr__nfet_01v8 w=1.47 l=0.15
xm12 N006 N005 VDD VDD sky130_fd_pr__pfet_01v8 w=1.47 l=0.15
xm13 N007 N006 0 0 sky130_fd_pr__nfet_01v8 w=1.47 l=0.15
xm14 N007 N006 VDD VDD sky130_fd_pr__pfet_01v8 w=1.47 l=0.15
xm15 N008 N007 0 0 sky130_fd_pr__nfet_01v8 w=1.47 l=0.15
xm16 N008 N007 VDD VDD sky130_fd_pr__pfet_01v8 w=1.47 l=0.15
xm17 N009 N008 0 0 sky130_fd_pr__nfet_01v8 w=1.47 l=0.15
xm18 N009 N008 VDD VDD sky130_fd_pr__pfet_01v8 w=1.47 l=0.15
xm19 N010 N009 0 0 sky130_fd_pr__nfet_01v8 w=1.47 l=0.15
xm20 N010 N009 VDD VDD sky130_fd_pr__pfet_01v8 w=1.47 l=0.15
xm21 Osc N010 0 0 sky130_fd_pr__nfet_01v8 w=1.47 l=0.15
xm22 Osc N010 VDD VDD sky130_fd_pr__pfet_01v8 w=1.47 l=0.15

.control
set filetype=ascii

op
let vdd_current = abs(i(VDD))
let power_dc = vdd_current * 1.8
let vnode_N001 = v(N001)
let vnode_N002 = v(N002)
let vnode_N003 = v(N003)
let vnode_N004 = v(N004)
let vnode_N005 = v(N005)
let vout_dc = vnode_N001
print power_dc vout_dc vnode_N001 vnode_N002 vnode_N003 vnode_N004 vnode_N005

let vout_dc = v(N009)
print vout_dc
let vout_dc = v(N003)
print vout_dc
quit
.endc

.end
