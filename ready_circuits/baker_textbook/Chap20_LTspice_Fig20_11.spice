* Circuit: Chap20_LTspice/Fig20_11
.lib ${SKY130_PDK} tt

xm2 0 N001 VDD VDD sky130_fd_pr__pfet_01v8 w=1.47 l=0.15
xm1 N001 N001 VDD VDD sky130_fd_pr__pfet_01v8 w=1.47 l=0.15
VDD VDD 0 1.8
IREF N001 0 10µ

.control
set filetype=ascii

op
let vdd_current = abs(i(VDD))
let power_dc = vdd_current * 1.8
let vnode_N001 = v(N001)
let vout_dc = vnode_N001
print power_dc vout_dc vnode_N001

let vout_dc = v(N001)
print vout_dc
let vout_dc = v(N001)
print vout_dc
quit
.endc

.end
