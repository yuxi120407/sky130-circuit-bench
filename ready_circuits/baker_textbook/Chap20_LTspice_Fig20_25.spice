* Circuit: Chap20_LTspice/Fig20_25
.lib ${SKY130_PDK} tt

xm2 0 VD1 VDD VDD sky130_fd_pr__pfet_01v8 w=1.47 l=0.15
xm1 VD1 VD1 VDD VDD sky130_fd_pr__pfet_01v8 w=1.47 l=0.15
VDD VDD 0 1.8
IREF VD1 0 10µ

.control
set filetype=ascii

op
let vdd_current = abs(i(VDD))
let power_dc = vdd_current * 1.8
let vnode_VD1 = v(VD1)
let vout_dc = vnode_VD1
print power_dc vout_dc vnode_VD1

let vout_dc = v(VD1)
print vout_dc
let vout_dc = v(VD1)
print vout_dc
quit
.endc

.end
