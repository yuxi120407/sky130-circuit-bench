* Circuit: Chap21_LTspice/Fig21_17
.lib ${SKY130_PDK} tt

VDD VDD 0 1.8
xm1 Vout Vi 0 0 sky130_fd_pr__nfet_01v8 w=1.47 l=2
xm2 Vout Vbias1 VDD VDD sky130_fd_pr__pfet_01v8 w=1.47 l=2
X_U1 Vbias1 Vhigh Vbias2 Vpcas Vncas Vbias3 Vlow Vbias4 VDD 0 Fig_20_43
Vi Vi 0 0
.subckt Fig_20_43 Vbias1 Vhigh Vbias2 Vpcas Vncas Vbias3 Vlow Vbias4 VDD GND
  xmsu2 N001 N001 VDD VDD sky130_fd_pr__pfet_01v8 w=10 l=20
  xmsu1 N001 Vbiasn 0 0 sky130_fd_pr__nfet_01v8 w=10 l=2
  xmsu3 N002 N001 Vbiasn 0 sky130_fd_pr__nfet_01v8 w=10 l=1
  xm3 Vbiasn N002 VDD VDD sky130_fd_pr__pfet_01v8 w=30 l=2
  xm4 N002 N002 VDD VDD sky130_fd_pr__pfet_01v8 w=30 l=2
  xm1 Vbiasn Vbiasn 0 0 sky130_fd_pr__nfet_01v8 w=10 l=2
  xm2 N002 Vbiasn N003 0 sky130_fd_pr__nfet_01v8 w=40 l=2
  R1 N003 0 6.5k
  xm5 Vbias2 Vbias2 VDD VDD sky130_fd_pr__pfet_01v8 w=30 l=10
  xm6 Vbias2 Vbiasn 0 0 sky130_fd_pr__nfet_01v8 w=10 l=2
  xm7 N005 Vbias1 VDD VDD sky130_fd_pr__pfet_01v8 w=30 l=2
  xm8 Vbias1 Vbiasn 0 0 sky130_fd_pr__nfet_01v8 w=10 l=2
  xm9 Vbias1 Vbias2 N005 VDD sky130_fd_pr__pfet_01v8 w=30 l=2
  xm10 Vhigh Vbias1 VDD VDD sky130_fd_pr__pfet_01v8 w=30 l=2
  xm11 Vncas Vbias2 Vhigh VDD sky130_fd_pr__pfet_01v8 w=30 l=2
  xm12 Vncas Vncas N009 0 sky130_fd_pr__nfet_01v8 w=10 l=2
  xm13 N009 Vbias3 N010 0 sky130_fd_pr__nfet_01v8 w=10 l=2
  xm14 N010 N009 GND 0 sky130_fd_pr__nfet_01v8 w=10 l=2
  xm15 N006 Vbias1 VDD VDD sky130_fd_pr__pfet_01v8 w=30 l=2
  xm16 Vbias3 Vbias2 N006 VDD sky130_fd_pr__pfet_01v8 w=30 l=2
  xm17 N007 Vbias1 VDD VDD sky130_fd_pr__pfet_01v8 w=30 l=2
  xm18 Vbias4 Vbias2 N007 VDD sky130_fd_pr__pfet_01v8 w=30 l=2
  xm19 N008 N004 VDD VDD sky130_fd_pr__pfet_01v8 w=30 l=2
  xm20 N004 Vbias2 N008 VDD sky130_fd_pr__pfet_01v8 w=30 l=2
  xm21 Vpcas Vpcas N004 VDD sky130_fd_pr__pfet_01v8 w=30 l=2
  xm22 Vbias3 Vbias3 0 0 sky130_fd_pr__nfet_01v8 w=10 l=10
  xm23 Vpcas Vbias3 N011 0 sky130_fd_pr__nfet_01v8 w=10 l=2
  xm24 N011 Vbias4 0 0 sky130_fd_pr__nfet_01v8 w=10 l=2
  xm25 Vbias4 Vbias3 Vlow 0 sky130_fd_pr__nfet_01v8 w=10 l=2
  xm26 Vlow Vbias4 0 0 sky130_fd_pr__nfet_01v8 w=10 l=2
.ends Fig_20_43

.control
dc Vi 0 1.8 0.0036

let vout_deriv = deriv(v(Vout))
let gain_linear = abs(vout_deriv)
let gain_db = db(gain_linear)
meas dc dc_gain_db MAX gain_db

let vdd_current = abs(i(VDD))
let power_dc = mean(vdd_current) * 1.8
print dc_gain_db power_dc

quit
.endc

.end
