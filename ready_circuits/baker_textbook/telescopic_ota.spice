* CIRCUIT: telescopic_ota
* YAML: /home/idies/workspace/Storage/xyu1/persistent/ALIGN-public/simple_circuit_5/OpenManus/autosizer_plus/circuits_yaml/telescopic_ota.yaml
* Variables: ['W_tail_base', 'W_diff_base', 'W_casc_base', 'W_load_base']
* Trial values (midpoint): [1.68, 1.68, 1.68, 1.68]
* Metrics: ['dc_gain_db', 'ugbw', 'power_dc', 'fom']
* Class: unknown

* Telescopic OTA Simulation
  .lib ${SKY130_PDK} tt

  .subckt TELESCOPIC_OTA VBIASN VBIASNC VBIASP1 VBIASP2 VINN VINP VOUTN VOUTP VDD 0
* Tail current sources
xm1 ID   VBIASN  0   0  sky130_fd_pr__nfet_01v8 w=3.36 l=0.15
xm2 NET10 VBIASN 0   0  sky130_fd_pr__nfet_01v8 w=3.36 l=0.15

* Differential pair
xm3 NET8   VINP NET10 0 sky130_fd_pr__nfet_01v8 w=6.72 l=0.15
xm4 NET014 VINN NET10 0 sky130_fd_pr__nfet_01v8 w=6.72 l=0.15

* NMOS cascode  (use VBIASNC here)
xm5 VOUTN VBIASNC NET8   0 sky130_fd_pr__nfet_01v8 w=3.36 l=0.15
xm6 VOUTP VBIASNC NET014 0 sky130_fd_pr__nfet_01v8 w=3.36 l=0.15

* PMOS cascode
xm7 VOUTN VBIASP1 NET06 VDD sky130_fd_pr__pfet_01v8 w=3.36 l=0.15
xm8 VOUTP VBIASP1 NET012 VDD sky130_fd_pr__pfet_01v8 w=3.36 l=0.15

* PMOS current source
xm9  NET06 VBIASP2 VDD VDD sky130_fd_pr__pfet_01v8 w=3.36 l=0.15
xm10 NET012 VBIASP2 VDD VDD sky130_fd_pr__pfet_01v8 w=3.36 l=0.15
.ends TELESCOPIC_OTA

  * Power supply
  VDD VDD 0 DC 1.8

  * Bias Generation
  IBIAS_N VDD VBIASN DC 10e-6
  XMN_BIAS VBIASN VBIASN 0 0 sky130_fd_pr__nfet_01v8 w=3.36 l=0.15

  IBIAS_P VBIASP2 0 DC 10e-6
  XMP_BIAS VBIASP2 VBIASP2 VDD VDD sky130_fd_pr__pfet_01v8 w=3.36 l=0.15

  VBIASP1 VBIASP1 0 DC=1.15

  * NEW: NMOS cascode bias (a bit higher than VBIASN)
  IBIAS_NC VDD VBIASNC DC 10e-6
  XMN_BIASC VBIASNC VBIASNC 0 0 sky130_fd_pr__nfet_01v8 w=3.36 l=0.15

  * Differential inputs
  VINP VINP 0 DC 0.7 AC 0.5
  VINN VINN 0 DC 0.7 AC -0.5

  * OTA instance
  XOTA VBIASN VBIASNC VBIASP1 VBIASP2 VINN VINP VOUTN VOUTP VDD 0 TELESCOPIC_OTA

  * Load capacitors
  CLOADP VOUTP 0 1e-12
  CLOADN VOUTN 0 1e-12

  .op

  .control
  op

  * Power
  let vdd_current = abs(i(VDD))
  let power_dc = vdd_current * 1.8
  echo "=== POWER ==="
  print vdd_current power_dc

  * AC analysis
  ac dec 100 1 10g

  let vout_diff = v(VOUTP) - v(VOUTN)
  let gain_db = db(vout_diff)

  let dc_gain_db = gain_db[0]

  echo "=== DC GAIN ==="
  print dc_gain_db

  * UGBW
  if dc_gain_db > 0
      meas ac ugbw WHEN gain_db=0 CROSS=1
  end

  quit
  .endc
  .end
