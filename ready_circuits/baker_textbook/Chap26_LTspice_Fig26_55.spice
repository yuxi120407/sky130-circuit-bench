* Circuit: Chap26_LTspice/Fig26_55
.lib ${SKY130_PDK} tt

VDD VDD 0 1.8
xm2 vomd Vbias1 N007 0 sky130_fd_pr__nfet_01v8 w=1.47 l=0.15
xm3 Vbias1 Vbias2 N003 VDD sky130_fd_pr__pfet_01v8 w=1.47 l=0.15
VCM VCM 0 500m
X_U1 Vbiasn Vbiasp VDD 0 Fig_26_3
xm6 N001 Vbias1 VDD VDD sky130_fd_pr__pfet_01v8 w=1.47 l=0.15
xm9 N003 Vbias1 VDD VDD sky130_fd_pr__pfet_01v8 w=1.47 l=0.15
xm10 Vbias2 Vbias2 VDD VDD sky130_fd_pr__pfet_01v8 w=1.47 l=0.15
xm13 Vbias1 Vbias1 N004 0 sky130_fd_pr__nfet_01v8 w=1.47 l=0.15
xm5 N006 Vbiasn 0 0 sky130_fd_pr__nfet_01v8 w=1.47 l=0.15
xm16 N005 Vbiasn 0 0 sky130_fd_pr__nfet_01v8 w=1.47 l=0.15
xm18 N004 VCM N005 0 sky130_fd_pr__nfet_01v8 w=1.47 l=0.15
xm19 Vbias2 VCM N006 0 sky130_fd_pr__nfet_01v8 w=1.47 l=0.15
xm1 N002 Vbias1 VDD VDD sky130_fd_pr__pfet_01v8 w=1.47 l=0.15
xm4 vomd Vbias2 N001 VDD sky130_fd_pr__pfet_01v8 w=1.47 l=0.15
xm7 vopd Vbias2 N002 VDD sky130_fd_pr__pfet_01v8 w=1.47 l=0.15
xm8 vopd Vbias1 N008 0 sky130_fd_pr__nfet_01v8 w=1.47 l=0.15
xm11 N007 vp N009 0 sky130_fd_pr__nfet_01v8 w=1.47 l=0.15
xm12 N008 vm N009 0 sky130_fd_pr__nfet_01v8 w=1.47 l=0.15
xm14 N009 Vbiasn 0 0 sky130_fd_pr__nfet_01v8 w=1.47 l=0.15
xm15 N009 VCMFB1 0 0 sky130_fd_pr__nfet_01v8 w=1.47 l=0.15
xm17 vomd phi1b vopd VDD sky130_fd_pr__pfet_01v8 w=1.47 l=0.15
Vphi1 phi1 0 Pulse 0 1 0 200p 200p 4n 10n
Vphi2 phi1b 0 Pulse 1 0 0 200p 200p 4n 10n
Vphi3 phi2 0 Pulse 0 1 5n 200p 200p 4n 10n
Vphi4 phi2b 0 Pulse 1 0 5n 200p 200p 4n 10n
xm20 vomd phi1 vopd 0 sky130_fd_pr__nfet_01v8 w=1.47 l=0.15
X_X1 Vbiasn Vbias1 vopd vomd phi1 phi1b phi2 phi2b VCMFB1 VDD 0 Fig_26_50
xm21 vp phi1b VCM VDD sky130_fd_pr__pfet_01v8 w=1.47 l=0.15
xm22 vp phi1 VCM 0 sky130_fd_pr__nfet_01v8 w=1.47 l=0.15
xm23 vm phi1b VCM VDD sky130_fd_pr__pfet_01v8 w=1.47 l=0.15
xm24 vm phi1 VCM 0 sky130_fd_pr__nfet_01v8 w=1.47 l=0.15
.subckt Fig_26_3 Vbiasn Vbiasp VDD GND
  xmsu2 N002 N002 VDD VDD sky130_fd_pr__pfet_01v8 w=1 l=0.15
  xmsu1 N002 Vbiasn GND 0 sky130_fd_pr__nfet_01v8 w=0.5 l=0.15
  xmsu3 Vbiasp N002 Vbiasn 0 sky130_fd_pr__nfet_01v8 w=1 l=0.15
  xm3 Vbiasn Vbiasp VDD VDD sky130_fd_pr__pfet_01v8 w=1 l=0.15
  xm4 N003 Vbiasp VDD VDD sky130_fd_pr__pfet_01v8 w=1 l=0.15
  xm1 Vbiasn Vbiasn 0 0 sky130_fd_pr__nfet_01v8 w=0.5 l=0.15
  R1 N004 0 4k
  xma4 Vbiasp N001 VDD VDD sky130_fd_pr__pfet_01v8 w=1 l=0.15
  xma3 N001 N001 VDD VDD sky130_fd_pr__pfet_01v8 w=1 l=0.15
  xm5 N001 N003 0 0 sky130_fd_pr__nfet_01v8 w=0.5 l=0.15
  xm7 VDD Vbiasp VDD VDD sky130_fd_pr__pfet_01v8 w=5 l=5
  xm2 Vbiasp Vbiasn 0 0 sky130_fd_pr__nfet_01v8 w=0.5 l=0.15
  xm6 N003 N003 N004 0 sky130_fd_pr__nfet_01v8 w=2 l=0.15
.ends Fig_26_3
.subckt Fig_26_50 ideal_vcmfb ideal_vcma Vop Vom phi1 phi1b phi2 phi2b VCMFB VDD GND
  xm1 ideal_vcma phi1 N001 GND sky130_fd_pr__nfet_01v8 w=0.5 l=0.15
  xm2 N001 phi1b ideal_vcma VDD sky130_fd_pr__pfet_01v8 w=0.5 l=0.15
  xm3 N001 phi2 vop 0 sky130_fd_pr__nfet_01v8 w=0.5 l=0.15
  xm4 vop phi2b N001 VDD sky130_fd_pr__pfet_01v8 w=0.5 l=0.15
  xm5 ideal_vcmfb phi1 N003 0 sky130_fd_pr__nfet_01v8 w=0.5 l=0.15
  xm6 N003 phi1b ideal_vcmfb VDD sky130_fd_pr__pfet_01v8 w=0.5 l=0.15
  xm7 N003 phi2 VCMFB 0 sky130_fd_pr__nfet_01v8 w=0.5 l=0.15
  xm8 VCMFB phi2b N003 VDD sky130_fd_pr__pfet_01v8 w=0.5 l=0.15
  C1 N001 N003 50f
  C2 vop VCMFB 10f
  xm9 ideal_vcma phi1 N002 0 sky130_fd_pr__nfet_01v8 w=0.5 l=0.15
  xm10 N002 phi1b ideal_vcma VDD sky130_fd_pr__pfet_01v8 w=0.5 l=0.15
  xm11 N002 phi2 vom 0 sky130_fd_pr__nfet_01v8 w=0.5 l=0.15
  xm12 vom phi2b N002 VDD sky130_fd_pr__pfet_01v8 w=0.5 l=0.15
  xm13 ideal_vcmfb phi1 N004 0 sky130_fd_pr__nfet_01v8 w=0.5 l=0.15
  xm14 N004 phi1b ideal_vcmfb VDD sky130_fd_pr__pfet_01v8 w=0.5 l=0.15
  xm15 N004 phi2 VCMFB 0 sky130_fd_pr__nfet_01v8 w=0.5 l=0.15
  xm16 VCMFB phi2b N004 VDD sky130_fd_pr__pfet_01v8 w=0.5 l=0.15
  C3 N002 N004 50f
  C4 vom VCMFB 10f
.ends Fig_26_50

.control
set filetype=ascii

op
let power_dc = abs(i(VDD)) * 1.8
let vout_dc = v(Vbiasp)
print power_dc vout_dc

quit
.endc

.end
