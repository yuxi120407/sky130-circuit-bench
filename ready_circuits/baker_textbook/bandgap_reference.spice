* Circuit: bandgap_reference
* Variables: W_mp, L_mp, W_mn, L_mn, L_ra, L_rb
* Metrics: vref, power_uw, psrr_100hz_db
.lib /home/idies/workspace/Temporary/xyu1/scratch/skywater-pdk-libs-sky130_fd_pr/combined_models/sky130.lib.spice tt
.include /home/idies/workspace/Temporary/xyu1/scratch/skywater-pdk-libs-sky130_fd_pr/cells/pnp_05v5/tests/sky130_fd_pr__pnp_05v5_W3p40L3p40__pnp.spice
.global VDD GND
.temp 27

*** Current Mirror (PMOS)
XMP1 NET1 NET2 VDD VDD sky130_fd_pr__pfet_01v8_lvt l=1 w=5 m=3
XMP2 NET2 NET2 VDD VDD sky130_fd_pr__pfet_01v8_lvt l=1 w=5 m=3
XMP3 NET3 NET2 VDD VDD sky130_fd_pr__pfet_01v8_lvt l=1 w=5 m=1

*** NMOS devices
XMN1 NET1 NET1 QP1 GND sky130_fd_pr__nfet_01v8_lvt l=0.5 w=5 m=2
XMN2 NET2 NET2 RA_TOP GND sky130_fd_pr__nfet_01v8_lvt l=0.5 w=5 m=2

*** Startup Circuit
XMP4 NET4 NET2 VDD VDD sky130_fd_pr__pfet_01v8_lvt l=1 w=5 m=1
XMP5 NET5 NET2 NET4 VDD sky130_fd_pr__pfet_01v8_lvt l=1 w=5 m=1
XMP6 NET7 NET6 NET2 VDD sky130_fd_pr__pfet_01v8_lvt l=1 w=5 m=2
XMN3 NET6 NET6 NET8 GND sky130_fd_pr__nfet_01v8_lvt l=7 w=1 m=1
XMN4 NET8 NET8 GND GND sky130_fd_pr__nfet_01v8_lvt l=7 w=1 m=1

*** BJTs
XQP1 GND GND QP1 VDD sky130_fd_pr__pnp_05v5_W3p40L3p40 m=1
XQP2 GND GND QP2 VDD sky130_fd_pr__pnp_05v5_W3p40L3p40 m=8
XQP3 GND GND QP3 VDD sky130_fd_pr__pnp_05v5_W3p40L3p40 m=1

*** Resistors
XRA RA_TOP QP2 VDD sky130_fd_pr__res_high_po_1p41 w=1.41 l=10
XRB NET3 QP3 VDD sky130_fd_pr__res_high_po_1p41 w=1.41 l=75

*** Measurement
VID3 QP3 VREF DC 0
VSUP VDD GND DC 2.0 AC 1

.control
set noaskquit

op
let vref = v(VREF)
let power_uw = abs(vsup#branch) * 2.0 * 1e6
print vref power_uw

ac dec 10 1 1Meg
let psrr_db = db(v(VDD)/v(VREF))
meas ac psrr_100hz_db FIND psrr_db AT=100
print psrr_100hz_db

quit
.endc

.end
