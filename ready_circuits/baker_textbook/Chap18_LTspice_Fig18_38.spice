* CIRCUIT: Chap18_LTspice_Fig18_38
* YAML: /home/idies/workspace/Storage/xyu1/persistent/ALIGN-public/simple_circuit_5/OpenManus/autosizer_plus/circuits_yaml_generated/Chap18_LTspice__Fig18_38.yaml
* Variables: ['W_nfet_g0', 'W_nfet_g1', 'W_M1', 'W_nfet_g2', 'W_nfet_g3', 'C1']
* Trial values (midpoint): [1.47, 1.47, 1.47, 1.47, 1.47, 1e-12]
* Metrics: ['avg_power', 'vout_swing', 'rise_time', 'fall_time', 'fom']
* Class: mosfet_analog_tran
* FOM: 6.56485198447059e-15
* FIXED: node rename {'vout': 'Vpump'}

* Circuit: Chap18_LTspice/Fig18_38
.lib ${SKY130_PDK} tt

xm19 N007 clk 0 0 sky130_fd_pr__nfet_01v8 w=1.47 l=0.15
Vclk clk 0 PULSE(1.8 0 0 10p 10p 5ns 10ns)
VDD VDD 0 1.8
xm18 N007 clk VDD VDD sky130_fd_pr__pfet_01v8 w=1.47 l=0.15
xm1 VDD VDD N001 0 sky130_fd_pr__nfet_01v8 w=1.47 l=0.15
xm2 N002 N001 N001 0 sky130_fd_pr__nfet_01v8 w=1.47 l=0.15
xm3 N003 N002 N002 0 sky130_fd_pr__nfet_01v8 w=1.47 l=0.15
xm4 N004 N003 N003 0 sky130_fd_pr__nfet_01v8 w=1.47 l=0.15
xm5 N005 N004 N004 0 sky130_fd_pr__nfet_01v8 w=1.47 l=0.15
xm6 N006 N005 N005 0 sky130_fd_pr__nfet_01v8 w=1.47 l=0.15
xm7 Vpump N006 N006 0 sky130_fd_pr__nfet_01v8 w=1.47 l=0.15
C1 Vpump 0 1e-12
xm8 N007 N001 N007 0 sky130_fd_pr__nfet_01v8 w=1.47 l=2
xm9 N009 N002 N009 0 sky130_fd_pr__nfet_01v8 w=1.47 l=2
xm10 N007 N003 N007 0 sky130_fd_pr__nfet_01v8 w=1.47 l=2
xm11 N009 N004 N009 0 sky130_fd_pr__nfet_01v8 w=1.47 l=2
xm12 N007 N005 N007 0 sky130_fd_pr__nfet_01v8 w=1.47 l=2
xm13 N009 N006 N009 0 sky130_fd_pr__nfet_01v8 w=1.47 l=2
xm14 N008 clk 0 0 sky130_fd_pr__nfet_01v8 w=1.47 l=0.15
xm15 N008 clk VDD VDD sky130_fd_pr__pfet_01v8 w=1.47 l=0.15
xm16 N009 N008 0 0 sky130_fd_pr__nfet_01v8 w=1.47 l=0.15
xm17 N009 N008 VDD VDD sky130_fd_pr__pfet_01v8 w=1.47 l=0.15

.control
tran 1p 100n

let power = v(VDD) * abs(i(VDD))
let avg_power = mean(power)
print avg_power

meas tran vout_max MAX v(Vpump)
meas tran vout_min MIN v(Vpump)
let vout_swing = vout_max - vout_min
print vout_swing

meas tran rise_time TRIG v(Vpump) VAL='0.1*vout_max' RISE=1 TARG v(Vpump) VAL='0.9*vout_max' RISE=1
meas tran fall_time TRIG v(Vpump) VAL='0.9*vout_max' FALL=1 TARG v(Vpump) VAL='0.1*vout_max' FALL=1
print rise_time fall_time

quit
.endc

.end
