* Circuit: Chap32_LTspice/Fig32_9
.lib ${SKY130_PDK} tt

X_X1 N004 N005 Vs Fig18_39
Vs Vs 0 5V
xmu Vs N005 Vout 0 sky130_fd_pr__nfet_01v8 w=1.47 l=1
xmd Vout N009 0 0 sky130_fd_pr__nfet_01v8 w=1.47 l=1
C1 Vout 0 1e-11
X_X2 N006 N009 Vs INV_240_80
X_X3 N001 N004 Vs INV_240_80
X_X4 N003 N001 Vs INV_30_10
X_X5 N008 N006 Vs INV_30_10
X_X6 N007 N008 Vs INV_30_10
X_X7 N002 N003 Vs INV_30_10
X_X8 Vin N010 Vs INV_30_10
X_X9 Vin N006 N002 Vs NAND_2
X_X10 N001 N010 N007 Vs NAND_2
V1 Vin 0 PULSE(0 1.8 10n 1n 1n 74n 100n)
.subckt Fig18_39 In Out VDD
  xm1i N001 In 0 0 sky130_fd_pr__nfet_01v8 w=80 l=1
  xm2i N001 In VDD VDD sky130_fd_pr__pfet_01v8 w=100 l=1
  C2 N002 B 5p
  xm1a N002 N001 0 0 sky130_fd_pr__nfet_01v8 w=80 l=1
  xm2a N002 N001 VDD VDD sky130_fd_pr__pfet_01v8 w=100 l=1
  xm3 Out N001 0 0 sky130_fd_pr__nfet_01v8 w=80 l=1
  xm4 Out N001 B B sky130_fd_pr__pfet_01v8 w=100 l=1
  C1 N001 A 1p
  xm2 B A VDD 0 sky130_fd_pr__nfet_01v8 w=80 l=1
  xm1 A B VDD 0 sky130_fd_pr__nfet_01v8 w=80 l=1
.ends Fig18_39
.subckt INV_240_80 In Out VDD
  xm1 Out In 0 0 sky130_fd_pr__nfet_01v8 w=80 l=1
  xm2 Out In VDD VDD sky130_fd_pr__pfet_01v8 w=100 l=1
.ends INV_240_80
.subckt INV_30_10 In Out VDD
  xm1 Out In 0 0 sky130_fd_pr__nfet_01v8 w=10 l=1
  xm2 Out In VDD VDD sky130_fd_pr__pfet_01v8 w=30 l=1
.ends INV_30_10
.subckt NAND_2 A B Out VDD
  xm3 out B VDD VDD sky130_fd_pr__pfet_01v8 w=30 l=1
  xm8 out A VDD VDD sky130_fd_pr__pfet_01v8 w=30 l=1
  xm11 N001 B 0 0 sky130_fd_pr__nfet_01v8 w=10 l=1
  xm12 out A N001 0 sky130_fd_pr__nfet_01v8 w=10 l=1
.ends NAND_2

.control
tran 1p 100n

let power = v(VDD) * abs(i(VDD))
let avg_power = mean(power)
print avg_power

meas tran vout_max MAX v(Vout)
meas tran vout_min MIN v(Vout)
let vout_swing = vout_max - vout_min
print vout_swing

meas tran rise_time TRIG v(Vout) VAL='0.1*vout_max' RISE=1 TARG v(Vout) VAL='0.9*vout_max' RISE=1
meas tran fall_time TRIG v(Vout) VAL='0.9*vout_max' FALL=1 TARG v(Vout) VAL='0.1*vout_max' FALL=1
print rise_time fall_time

quit
.endc

.end
