* CIRCUIT: Chap26_LTspice_Fig26_25
* YAML: /home/idies/workspace/Storage/xyu1/persistent/ALIGN-public/simple_circuit_5/OpenManus/autosizer_plus/circuits_yaml_generated/Chap26_LTspice__Fig26_25.yaml
* Variables: ['W_nfet_g0', 'W_nfet_g1', 'C1', 'C2', 'C3', 'C4', 'C5', 'C6']
* Trial values (midpoint): [1.47, 1.47, 5e-14, 5e-14, 2.5e-13, 2.5e-13, 2.5e-13, 2.5e-13]
* Metrics: ['avg_power', 'vout_swing', 'rise_time', 'fall_time', 'fom']
* Class: mosfet_analog_tran
* FOM: 1.7246971726968179e-12
* FIXED: node rename {'vout': 'voutm'}

* Circuit: Chap26_LTspice/Fig26_25
.lib ${SKY130_PDK} tt

VDD VDD 0 1.8
xm2 N001 N001 N005 0 sky130_fd_pr__nfet_01v8 w=1.47 l=0.15
xm1 N001 N001 N006 0 sky130_fd_pr__nfet_01v8 w=1.47 l=0.15
xm4 N001 Vbiasn N002 VDD sky130_fd_pr__pfet_01v8 w=1.47 l=0.15
xm3 vodm Vbiasn N003 VDD sky130_fd_pr__pfet_01v8 w=1.47 l=0.15
VCM VCM 0 500m
X_U1 Vbiasn Vbiasp VDD 0 Fig_26_3
xm6 N001 Vbiasn N002 VDD sky130_fd_pr__pfet_01v8 w=1.47 l=0.15
xm7 vodp Vbiasn N004 VDD sky130_fd_pr__pfet_01v8 w=1.47 l=0.15
xm8 N002 N001 VDD VDD sky130_fd_pr__pfet_01v8 w=1.47 l=0.15
xm9 N003 N001 VDD VDD sky130_fd_pr__pfet_01v8 w=1.47 l=0.15
xm10 N002 N001 VDD VDD sky130_fd_pr__pfet_01v8 w=1.47 l=0.15
xm11 N004 N001 VDD VDD sky130_fd_pr__pfet_01v8 w=1.47 l=0.15
xm12 vodp N001 ncr 0 sky130_fd_pr__nfet_01v8 w=1.47 l=0.15
xm13 vodm N001 ncl 0 sky130_fd_pr__nfet_01v8 w=1.47 l=0.15
xm5 N009 Vbiasn 0 0 sky130_fd_pr__nfet_01v8 w=1.47 l=0.15
xm14 N009 Vbiasn 0 0 sky130_fd_pr__nfet_01v8 w=1.47 l=0.15
xm15 N008 Vbiasn 0 0 sky130_fd_pr__nfet_01v8 w=1.47 l=0.15
xm16 N008 Vbiasn 0 0 sky130_fd_pr__nfet_01v8 w=1.47 l=0.15
xm17 ncr Vm N008 0 sky130_fd_pr__nfet_01v8 w=1.47 l=0.15
xm18 ncl Vp N008 0 sky130_fd_pr__nfet_01v8 w=1.47 l=0.15
xm19 N005 Vp N009 0 sky130_fd_pr__nfet_01v8 w=1.47 l=0.15
xm20 N006 Vm N009 0 sky130_fd_pr__nfet_01v8 w=1.47 l=0.15
xm21 vom vodp VDD VDD sky130_fd_pr__pfet_01v8 w=1.47 l=0.15
xm22 N012 vodm VDD VDD sky130_fd_pr__pfet_01v8 w=1.47 l=0.15
xm23 vom N012 0 0 sky130_fd_pr__nfet_01v8 w=1.47 l=0.15
xm24 N012 N012 0 0 sky130_fd_pr__nfet_01v8 w=1.47 l=0.15
C1 vom ncr 5e-14
xm25 vop vodm VDD VDD sky130_fd_pr__pfet_01v8 w=1.47 l=0.15
xm26 N011 vodp VDD VDD sky130_fd_pr__pfet_01v8 w=1.47 l=0.15
xm27 vop N011 0 0 sky130_fd_pr__nfet_01v8 w=1.47 l=0.15
xm28 N011 N011 0 0 sky130_fd_pr__nfet_01v8 w=1.47 l=0.15
C2 vop ncl 5e-14
Vinp Vinp 0 SIN 500m 100m 5MEG
Vinm Vinm 0 SIN 500m -100m 5MEG
xm30 vinp phi2 N007 0 sky130_fd_pr__nfet_01v8 w=1.47 l=0.15
C3 N007 Vm 2.5e-13
xm32 vinm phi2 N010 0 sky130_fd_pr__nfet_01v8 w=1.47 l=0.15
C4 N010 Vp 2.5e-13
xm34 N007 phi3 Vop 0 sky130_fd_pr__nfet_01v8 w=1.47 l=0.15
xm36 N010 phi3 Vom 0 sky130_fd_pr__nfet_01v8 w=1.47 l=0.15
xm38 Vm phi1 Vop 0 sky130_fd_pr__nfet_01v8 w=1.47 l=0.15
xm40 Vp phi1 Vom 0 sky130_fd_pr__nfet_01v8 w=1.47 l=0.15
xm42 Vop phi3 Voutp 0 sky130_fd_pr__nfet_01v8 w=1.47 l=0.15
xm44 Vom phi3 voutm 0 sky130_fd_pr__nfet_01v8 w=1.47 l=0.15
C5 Voutp 0 2.5e-13
C6 voutm 0 2.5e-13
Vphi1 phi1 0 PULSE(1.8 0 5n 0 0 5n 10n)
Vphi2 phi2 0 PULSE(1.8 0 5.2n 0 0 5n 10n)
Vphi3 phi3 0 PULSE(0 1.8 5.4n 0 0 4n 10n)
.subckt Fig_26_3 Vbiasn Vbiasp VDD GND
  xmsu2 N002 N002 VDD VDD sky130_fd_pr__pfet_01v8 w=1 l=0.15
  xmsu1 N002 Vbiasn GND 0 sky130_fd_pr__nfet_01v8 w=0.5 l=0.15
  xmsu3 Vbiasp N002 Vbiasn 0 sky130_fd_pr__nfet_01v8 w=1 l=0.15
  xm3 Vbiasn Vbiasp VDD VDD sky130_fd_pr__pfet_01v8 w=1 l=0.15
  xm4 N003 Vbiasp VDD VDD sky130_fd_pr__pfet_01v8 w=1 l=0.15
  xm1 Vbiasn Vbiasn 0 0 sky130_fd_pr__nfet_01v8 w=0.5 l=0.15
  R1 N004 0 4k
  xma4 Vbiasp N001 VDD VDD sky130_fd_pr__pfet_01v8 w=1 l=0.15
  xma3 N001 N001 VDD VDD sky130_fd_pr__pfet_01v8 w=1 l=0.15
  xm5 N001 N003 0 0 sky130_fd_pr__nfet_01v8 w=0.5 l=0.15
  xm7 VDD Vbiasp VDD VDD sky130_fd_pr__pfet_01v8 w=5 l=5
  xm2 Vbiasp Vbiasn 0 0 sky130_fd_pr__nfet_01v8 w=0.5 l=0.15
  xm6 N003 N003 N004 0 sky130_fd_pr__nfet_01v8 w=2 l=0.15
.ends Fig_26_3

.control
tran 1p 100n

let power = v(VDD) * abs(i(VDD))
let avg_power = mean(power)
print avg_power

meas tran vout_max MAX v(voutm)
meas tran vout_min MIN v(voutm)
let vout_swing = vout_max - vout_min
print vout_swing

meas tran rise_time TRIG v(voutm) VAL='0.1*vout_max' RISE=1 TARG v(voutm) VAL='0.9*vout_max' RISE=1
meas tran fall_time TRIG v(voutm) VAL='0.9*vout_max' FALL=1 TARG v(voutm) VAL='0.1*vout_max' FALL=1
print rise_time fall_time

quit
.endc

.end
