* CIRCUIT: Chap12_LTspice/Fig12_3
* YAML: /home/idies/workspace/Storage/xyu1/persistent/ALIGN-public/simple_circuit_5/OpenManus/autosizer_plus/circuits_yaml_generated/Chap12_LTspice__Fig12_3.yaml
* Variables: ['W_nfet_g0', 'W_pfet_g1']
* Trial values (midpoint): [1.47, 1.47]
* Metrics: ['dc_gain_db', 'power_dc', 'fom']
* Class: mosfet_analog_dc

* Circuit: Chap12_LTspice/Fig12_3
.lib ${SKY130_PDK} tt

xm2 P001 Vin P002 0 sky130_fd_pr__nfet_01v8 w=1.47 l=1
Vin Vin 0 0
VDD VDD 0 1.8
xm4 Vout Vin VDD VDD sky130_fd_pr__pfet_01v8 w=1.47 l=1
xm5 Vout Vin VDD VDD sky130_fd_pr__pfet_01v8 w=1.47 l=1
xm3 Vout Vin P001 0 sky130_fd_pr__nfet_01v8 w=1.47 l=1
xm1 P002 Vin 0 0 sky130_fd_pr__nfet_01v8 w=1.47 l=1
xm6 Vout Vin VDD VDD sky130_fd_pr__pfet_01v8 w=1.47 l=1

.control
dc VIN 0 1.8 0.0036

let vout_deriv = deriv(v(vout))
let gain_linear = abs(vout_deriv)
let gain_db = db(gain_linear)
meas dc dc_gain_db MAX gain_db

let vdd_current = abs(i(VDD))
let power_dc = mean(vdd_current) * 1.8
print dc_gain_db power_dc

quit
.endc

.end
