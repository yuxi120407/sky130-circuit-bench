* CIRCUIT: Chap17_LTspice_Fig17_12
* YAML: /home/idies/workspace/Storage/xyu1/persistent/ALIGN-public/simple_circuit_5/OpenManus/autosizer_plus/circuits_yaml_generated/Chap17_LTspice__Fig17_12.yaml
* Variables: ['W_nfet_g0', 'C1']
* Trial values (midpoint): [1.47, 1e-13]
* Metrics: ['avg_power', 'vout_swing', 'rise_time', 'fall_time', 'fom']
* Class: mosfet_digital_or_small
* FOM: 4.153783269463069e-11
* FIXED: node rename {'vout': 'N001'}

* Circuit: Chap17_LTspice/Fig17_12
.lib ${SKY130_PDK} tt

VDD VDD 0 1.8
xm3 N001 phi1 VDD VDD sky130_fd_pr__pfet_01v8 w=1.47 l=0.15
Vphi1 Phi1 0 PULSE(1.8 0 1n 10p 10p 4n 10n)
Vphi2 phi2 0 PULSE(1.8 0 6n 10p 10p 4n 10n)
xm1 N002 phi2 N001 VDD sky130_fd_pr__pfet_01v8 w=1.47 l=0.15
xm2 N003 0 N002 VDD sky130_fd_pr__pfet_01v8 w=1.47 l=0.15
Vbit vbit 0 PULSE(0.54 1.08 0 1000n 1 1)
C1 N001 0 1e-13
xm4 vbit VREF N003 N003 sky130_fd_pr__pfet_01v8 w=1.47 l=0.15
VREF VREF 0 500m

.control
tran 1p 100n

let power = v(VDD) * abs(i(VDD))
let avg_power = mean(power)
print avg_power

meas tran vout_max MAX v(N001)
meas tran vout_min MIN v(N001)
let vout_swing = vout_max - vout_min
print vout_swing

meas tran rise_time TRIG v(N001) VAL='0.1*vout_max' RISE=1 TARG v(N001) VAL='0.9*vout_max' RISE=1
meas tran fall_time TRIG v(N001) VAL='0.9*vout_max' FALL=1 TARG v(N001) VAL='0.1*vout_max' FALL=1
print rise_time fall_time

quit
.endc

.end
