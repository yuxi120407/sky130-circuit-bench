* CIRCUIT: Chap24_LTspice/Fig24_63_pulse_Cc2=2400f
* YAML: /home/idies/workspace/Storage/xyu1/persistent/ALIGN-public/simple_circuit_5/OpenManus/autosizer_plus/circuits_yaml_generated/Chap24_LTspice__Fig24_63_pulse_Cc2=2400f.yaml
* Variables: ['W_nfet_g0', 'W_nfet_g1', 'Cc1', 'Cc2', 'C1']
* Trial values (midpoint): [1.47, 1.47, 2.4e-13, 2.4e-12, 1e-12]
* Metrics: ['avg_power', 'vout_swing', 'rise_time', 'fall_time', 'fom']
* Class: mosfet_analog_tran

* Circuit: Chap24_LTspice/Fig24_63_pulse_Cc2=2400f
.lib ${SKY130_PDK} tt

VDD VDD 0 1.8
vp Vin 0 PULSE(500m 600m 500n 100p 100p 100n 2u) AC 1
xm28 N001 N001 N004 VDD sky130_fd_pr__pfet_01v8 w=1.47 l=0.15
xm1 N010 Vbiasn 0 0 sky130_fd_pr__nfet_01v8 w=1.47 l=0.15
xm2 N010 Vbiasn 0 0 sky130_fd_pr__nfet_01v8 w=1.47 l=0.15
xm3 N001 Vout N010 0 sky130_fd_pr__nfet_01v8 w=1.47 l=0.15
xm4 N009 Vin N010 0 sky130_fd_pr__nfet_01v8 w=1.47 l=0.15
xm5 N004 N001 VDD VDD sky130_fd_pr__pfet_01v8 w=1.47 l=0.15
xm6 N009 N001 N005 VDD sky130_fd_pr__pfet_01v8 w=1.47 l=0.15
xm7 N005 N001 VDD VDD sky130_fd_pr__pfet_01v8 w=1.47 l=0.15
xm8 N002 N002 N006 VDD sky130_fd_pr__pfet_01v8 w=1.47 l=0.15
xm9 N011 Vbiasn 0 0 sky130_fd_pr__nfet_01v8 w=1.47 l=0.15
xm10 N011 Vbiasn 0 0 sky130_fd_pr__nfet_01v8 w=1.47 l=0.15
xm11 N002 N009 N011 0 sky130_fd_pr__nfet_01v8 w=1.47 l=0.15
xm12 N003 N001 N011 0 sky130_fd_pr__nfet_01v8 w=1.47 l=0.15
xm13 N006 N002 VDD VDD sky130_fd_pr__pfet_01v8 w=1.47 l=0.15
xm14 N003 N002 N007 VDD sky130_fd_pr__pfet_01v8 w=1.47 l=0.15
xm15 N007 N002 VDD VDD sky130_fd_pr__pfet_01v8 w=1.47 l=0.15
xm16 Vout Vbiasn 0 0 sky130_fd_pr__nfet_01v8 w=1.47 l=0.15
xm18 Vout N003 N008 VDD sky130_fd_pr__pfet_01v8 w=1.47 l=0.15
xm19 N008 N003 VDD VDD sky130_fd_pr__pfet_01v8 w=1.47 l=0.15
Cc1 N003 N001 2.4e-13
Cc2 Vout N005 2.4e-12
X_U1 Vbiasn Vbiasp VDD 0 Fig_20_22
C1 Vout 0 1e-12
.subckt Fig_20_22 Vbiasn Vbiasp VDD GND
  xmsu2 N002 N002 VDD VDD sky130_fd_pr__pfet_01v8 w=1 l=0.15
  xmsu1 N002 Vbiasn GND 0 sky130_fd_pr__nfet_01v8 w=1 l=0.15
  xmsu3 Vbiasp N002 Vbiasn 0 sky130_fd_pr__nfet_01v8 w=1 l=0.15
  xm3 Vbiasn Vbiasp VDD VDD sky130_fd_pr__pfet_01v8 w=5 l=0.15
  xm4 N003 Vbiasp VDD VDD sky130_fd_pr__pfet_01v8 w=5 l=0.15
  xm1 Vbiasn Vbiasn 0 0 sky130_fd_pr__nfet_01v8 w=1 l=0.15
  R1 N004 0 5.5k
  xma4 Vbiasp N001 VDD VDD sky130_fd_pr__pfet_01v8 w=5 l=0.15
  xma3 N001 N001 VDD VDD sky130_fd_pr__pfet_01v8 w=5 l=0.15
  xm5 N001 N003 0 0 sky130_fd_pr__nfet_01v8 w=1 l=0.15
  xm7 VDD Vbiasp VDD VDD sky130_fd_pr__pfet_01v8 w=5 l=5
  xm8 0 Vbiasn 0 0 sky130_fd_pr__nfet_01v8 w=5 l=5
  xm2 Vbiasp Vbiasn 0 0 sky130_fd_pr__nfet_01v8 w=1 l=0.15
  xm6 N003 N003 N004 0 sky130_fd_pr__nfet_01v8 w=10 l=0.15
.ends Fig_20_22

.control
tran 1p 100n

let power = v(VDD) * abs(i(VDD))
let avg_power = mean(power)
print avg_power

meas tran vout_max MAX v(vout)
meas tran vout_min MIN v(vout)
let vout_swing = vout_max - vout_min
print vout_swing

meas tran rise_time TRIG v(vout) VAL='0.1*vout_max' RISE=1 TARG v(vout) VAL='0.9*vout_max' RISE=1
meas tran fall_time TRIG v(vout) VAL='0.9*vout_max' FALL=1 TARG v(vout) VAL='0.1*vout_max' FALL=1
print rise_time fall_time

quit
.endc

.end
