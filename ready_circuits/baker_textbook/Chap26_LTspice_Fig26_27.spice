* Circuit: Chap26_LTspice/Fig26_27
.lib ${SKY130_PDK} tt

VDD VDD 0 1.8
xm2 N001 N001 N005 0 sky130_fd_pr__nfet_01v8 w=1.47 l=0.15
xm1 N001 N001 N006 0 sky130_fd_pr__nfet_01v8 w=1.47 l=0.15
xm4 N001 Vbiasn N002 VDD sky130_fd_pr__pfet_01v8 w=1.47 l=0.15
xm3 vodm Vbiasn N003 VDD sky130_fd_pr__pfet_01v8 w=1.47 l=0.15
VCM VCM 0 500m
X_U1 Vbiasn Vbiasp VDD 0 Fig_26_3
xm6 N001 Vbiasn N002 VDD sky130_fd_pr__pfet_01v8 w=1.47 l=0.15
xm7 vodp Vbiasn N004 VDD sky130_fd_pr__pfet_01v8 w=1.47 l=0.15
xm8 N002 N001 VDD VDD sky130_fd_pr__pfet_01v8 w=1.47 l=0.15
xm9 N003 N001 VDD VDD sky130_fd_pr__pfet_01v8 w=1.47 l=0.15
xm10 N002 N001 VDD VDD sky130_fd_pr__pfet_01v8 w=1.47 l=0.15
xm11 N004 N001 VDD VDD sky130_fd_pr__pfet_01v8 w=1.47 l=0.15
xm12 vodp N001 ncr 0 sky130_fd_pr__nfet_01v8 w=1.47 l=0.15
xm13 vodm N001 ncl 0 sky130_fd_pr__nfet_01v8 w=1.47 l=0.15
xm5 N008 Vbiasn 0 0 sky130_fd_pr__nfet_01v8 w=1.47 l=0.15
xm14 N008 VCMFB 0 0 sky130_fd_pr__nfet_01v8 w=1.47 l=0.15
xm15 N007 Vbiasn 0 0 sky130_fd_pr__nfet_01v8 w=1.47 l=0.15
xm16 N007 Vbiasn 0 0 sky130_fd_pr__nfet_01v8 w=1.47 l=0.15
xm17 ncr VCM N007 0 sky130_fd_pr__nfet_01v8 w=1.47 l=0.15
xm18 ncl VCM N007 0 sky130_fd_pr__nfet_01v8 w=1.47 l=0.15
xm19 N005 VCM N008 0 sky130_fd_pr__nfet_01v8 w=1.47 l=0.15
xm20 N006 VCM N008 0 sky130_fd_pr__nfet_01v8 w=1.47 l=0.15
xm21 vom vodp VDD VDD sky130_fd_pr__pfet_01v8 w=1.47 l=0.15
xm22 N010 vodm VDD VDD sky130_fd_pr__pfet_01v8 w=1.47 l=0.15
xm23 vom N010 0 0 sky130_fd_pr__nfet_01v8 w=1.47 l=0.15
xm24 N010 N010 0 0 sky130_fd_pr__nfet_01v8 w=1.47 l=0.15
C1 vom ncr 5e-14
xm25 vop vodm VDD VDD sky130_fd_pr__pfet_01v8 w=1.47 l=0.15
xm26 N009 vodp VDD VDD sky130_fd_pr__pfet_01v8 w=1.47 l=0.15
xm27 vop N009 0 0 sky130_fd_pr__nfet_01v8 w=1.47 l=0.15
xm28 N009 N009 0 0 sky130_fd_pr__nfet_01v8 w=1.47 l=0.15
C2 vop ncl 5e-14
VCMFB VCMFB 0 500m
.subckt Fig_26_3 Vbiasn Vbiasp VDD GND
  xmsu2 N002 N002 VDD VDD sky130_fd_pr__pfet_01v8 w=1 l=0.15
  xmsu1 N002 Vbiasn GND 0 sky130_fd_pr__nfet_01v8 w=0.5 l=0.15
  xmsu3 Vbiasp N002 Vbiasn 0 sky130_fd_pr__nfet_01v8 w=1 l=0.15
  xm3 Vbiasn Vbiasp VDD VDD sky130_fd_pr__pfet_01v8 w=1 l=0.15
  xm4 N003 Vbiasp VDD VDD sky130_fd_pr__pfet_01v8 w=1 l=0.15
  xm1 Vbiasn Vbiasn 0 0 sky130_fd_pr__nfet_01v8 w=0.5 l=0.15
  R1 N004 0 4k
  xma4 Vbiasp N001 VDD VDD sky130_fd_pr__pfet_01v8 w=1 l=0.15
  xma3 N001 N001 VDD VDD sky130_fd_pr__pfet_01v8 w=1 l=0.15
  xm5 N001 N003 0 0 sky130_fd_pr__nfet_01v8 w=0.5 l=0.15
  xm7 VDD Vbiasp VDD VDD sky130_fd_pr__pfet_01v8 w=5 l=5
  xm2 Vbiasp Vbiasn 0 0 sky130_fd_pr__nfet_01v8 w=0.5 l=0.15
  xm6 N003 N003 N004 0 sky130_fd_pr__nfet_01v8 w=2 l=0.15
.ends Fig_26_3

.control
set filetype=ascii

op
let power_dc = abs(i(VDD)) * 1.8
let vout_dc = v(Vbiasp)
print power_dc vout_dc

quit
.endc

.end
