* Circuit: Chap20_LTspice/Fig20_33
.lib ${SKY130_PDK} tt

VDD VDD 0 1.8
xm1 N003 N003 0 0 sky130_fd_pr__nfet_01v8 w=1.47 l=2
Vo N001 0 0
X_U1 Vbiasn Vbiasp VDD 0 Fig_20_15
xmws N002 N002 0 0 sky130_fd_pr__nfet_01v8 w=1.47 l=8
xm2 N004 N003 0 0 sky130_fd_pr__nfet_01v8 w=1.47 l=2
xm4 N001 N002 N004 0 sky130_fd_pr__nfet_01v8 w=1.47 l=2
xm5 N002 Vbiasp VDD VDD sky130_fd_pr__pfet_01v8 w=1.47 l=2
xm6 N003 Vbiasp VDD VDD sky130_fd_pr__pfet_01v8 w=1.47 l=2
.subckt Fig_20_15 Vbiasn Vbiasp VDD GND
  xmsu2 N001 N001 VDD VDD sky130_fd_pr__pfet_01v8 w=10 l=20
  xmsu1 N001 Vbiasn 0 0 sky130_fd_pr__nfet_01v8 w=10 l=2
  xmsu3 Vbiasp N001 Vbiasn 0 sky130_fd_pr__nfet_01v8 w=10 l=1
  xm3 Vbiasn Vbiasp VDD VDD sky130_fd_pr__pfet_01v8 w=30 l=2
  xm4 Vbiasp Vbiasp VDD VDD sky130_fd_pr__pfet_01v8 w=30 l=2
  xm1 Vbiasn Vbiasn 0 0 sky130_fd_pr__nfet_01v8 w=10 l=2
  xm2 Vbiasp Vbiasn N002 0 sky130_fd_pr__nfet_01v8 w=40 l=2
  R1 N002 GND 6.5k
.ends Fig_20_15

.control
dc Vo 0 1.8 0.0018

let iout = abs(i(Vo))
let iout_deriv = deriv(iout)
let rout = 1.0 / abs(iout_deriv)

meas dc iout_mid FIND iout AT=0.9
meas dc rout_mid FIND rout AT=0.9

let vdd_current = abs(i(VDD))
let power_dc = mean(vdd_current) * 1.8
print iout_mid rout_mid power_dc

quit
.endc

.end
