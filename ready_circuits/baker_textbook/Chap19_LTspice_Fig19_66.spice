* CIRCUIT: Chap19_LTspice_Fig19_66
* YAML: /home/idies/workspace/Storage/xyu1/persistent/ALIGN-public/simple_circuit_5/OpenManus/autosizer_plus/circuits_yaml_generated/Chap19_LTspice__Fig19_66.yaml
* Variables: ['W_nfet_g0', 'W_nfet_g1', 'W_nfet_g2', 'W_nfet_g3', 'C2']
* Trial values (midpoint): [1.47, 1.47, 1.47, 1.47, 5e-12]
* Metrics: ['avg_power', 'vout_swing', 'rise_time', 'fall_time', 'fom']
* Class: mosfet_analog_tran
* FOM: 2.3681528432542373e-15
* FIXED: node rename {'vout': 'out'}

* Circuit: Chap19_LTspice/Fig19_66
.lib ${SKY130_PDK} tt

Vin In 0 PULSE(0 1.8 0 10p 10p 0.2n 0.5n)
VDD VDD 0 1.8
X_U4 up upi VDD 0 INV_20_10
X_U1 In Out up down VDD 0 PFD
xm1 Vindel down N005 0 sky130_fd_pr__nfet_01v8 w=1.47 l=0.15
xm2 Vindel upi N002 VDD sky130_fd_pr__pfet_01v8 w=1.47 l=0.15
X_U5 down downi VDD 0 INV_20_10
C2 Vindel 0 5e-12
xm3 N003 downi N005 0 sky130_fd_pr__nfet_01v8 w=1.47 l=0.15
xm4 N003 up N002 VDD sky130_fd_pr__pfet_01v8 w=1.47 l=0.15
xm5 N002 N001 VDD VDD sky130_fd_pr__pfet_01v8 w=1.47 l=0.15
xm6 N001 N001 VDD VDD sky130_fd_pr__pfet_01v8 w=1.47 l=0.15
xm7 N005 N004 0 0 sky130_fd_pr__nfet_01v8 w=1.47 l=0.15
xm8 N004 N004 0 0 sky130_fd_pr__nfet_01v8 w=1.47 l=0.15
I1 N001 N004 10µ
Vref Vref 0 500m
X_U2 n1 n2 Out Outi Vindel Vref VDD 0 Fig_19_63
X_U3 In n2 VDD 0 INV_20_10
xm9 In 0 n1 VDD sky130_fd_pr__pfet_01v8 w=1.47 l=0.15
xm10 In VDD n1 0 sky130_fd_pr__nfet_01v8 w=1.47 l=0.15
.subckt INV_20_10 In Out VDD GND
  xm1 Out In GND GND sky130_fd_pr__nfet_01v8 w=0.5 l=0.15
  xm2 Out In VDD VDD sky130_fd_pr__pfet_01v8 w=1 l=0.15
.ends INV_20_10
.subckt PFD data dclock up down VDD GND
  X_U1 data N004 VDD GND INV_20_10
  X_U2 N001 N004 B VDD 0 NAND_2
  X_U3 B N002 VDD 0 INV_20_10
  X_U4 N002 N003 VDD 0 INV_20_10
  X_U5 N003 A reset N001 VDD 0 NAND_3
  X_U6 N001 up VDD 0 INV_20_10
  X_U7 B N005 A VDD 0 NAND_2
  X_U8 A reset N005 VDD 0 NAND_2
  X_U9 dclock N009 VDD 0 INV_20_10
  X_U10 N006 N009 C VDD 0 NAND_2
  X_U11 C N007 VDD 0 INV_20_10
  X_U12 N007 N008 VDD 0 INV_20_10
  X_U13 N008 D reset N006 VDD 0 NAND_3
  X_U14 N006 down VDD 0 INV_20_10
  X_U15 C N010 D VDD 0 NAND_2
  X_U16 D reset N010 VDD 0 NAND_2
  X_U17 A B C D reset VDD 0 NAND_4
.ends PFD
.subckt Fig_19_63 Inp Inm Outp Outm Vindel Vref VDD GND
  xm1 N013 N013 GND 0 sky130_fd_pr__nfet_01v8 w=0.5 l=0.15
  xm3 N013 n2 N011 VDD sky130_fd_pr__pfet_01v8 w=1 l=0.15
  xm4 Vrbias VREF N011 VDD sky130_fd_pr__pfet_01v8 w=1 l=0.15
  xm2 Vrbias N013 0 0 sky130_fd_pr__nfet_01v8 w=0.5 l=0.15
  xm5 Vpbias Vpbias VDD VDD sky130_fd_pr__pfet_01v8 w=1 l=0.15
  xm7 n2 Vrbias 0 0 sky130_fd_pr__nfet_01v8 w=0.5 l=0.15
  xm6 N011 N013 VDD VDD sky130_fd_pr__pfet_01v8 w=1 l=0.15
  xmref Vpbias Vindel P001 0 sky130_fd_pr__nfet_01v8 w=5 l=0.15
  R1 P001 0 10k
  xm8 N009 Vpbias VDD VDD sky130_fd_pr__pfet_01v8 w=10 l=0.15
  xm9 n2 0 N009 VDD sky130_fd_pr__pfet_01v8 w=1 l=0.15
  xm10 n2 n2 0 0 sky130_fd_pr__nfet_01v8 w=0.5 l=0.15
  X_U12 N010 Outm VDD 0 INV_20_10
  X_U13 N012 Outp VDD 0 INV_20_10
  X_X1 Out4 Out4i N001 N002 Vpbias Vrbias VDD 0 delay
  X_X2 N001 N002 Out6 N003 Vpbias Vrbias VDD 0 delay
  X_X3 Out6 N003 Out7 Out7i Vpbias Vrbias VDD 0 delay
  X_X4 Out2 N007 N005 N008 Vpbias Vrbias VDD 0 delay
  X_X5 N005 N008 Out4 Out4i Vpbias Vrbias VDD 0 delay
  X_X6 N004 N006 Out2 N007 Vpbias Vrbias VDD 0 delay
  X_X7 Inp Inm N004 N006 Vpbias Vrbias VDD 0 delay
  X_X8 Out7 Out7i N010 Vpbias VDD 0 pdiff
  X_X9 Out7i Out7 N012 Vpbias VDD 0 pdiff
.ends Fig_19_63
.subckt NAND_2 A B Out VDD GND
  xm3 out B VDD VDD sky130_fd_pr__pfet_01v8 w=1 l=0.15
  xm8 out A VDD VDD sky130_fd_pr__pfet_01v8 w=1 l=0.15
  xm11 N001 B GND 0 sky130_fd_pr__nfet_01v8 w=0.5 l=0.15
  xm12 out A N001 0 sky130_fd_pr__nfet_01v8 w=0.5 l=0.15
.ends NAND_2
.subckt NAND_3 A B C Out VDD GND
  xm3 out B VDD VDD sky130_fd_pr__pfet_01v8 w=1 l=0.15
  xm7 out C VDD VDD sky130_fd_pr__pfet_01v8 w=1 l=0.15
  xm8 out A VDD VDD sky130_fd_pr__pfet_01v8 w=1 l=0.15
  xm10 N002 C GND 0 sky130_fd_pr__nfet_01v8 w=0.5 l=0.15
  xm11 N001 B N002 0 sky130_fd_pr__nfet_01v8 w=0.5 l=0.15
  xm12 out A N001 0 sky130_fd_pr__nfet_01v8 w=0.5 l=0.15
.ends NAND_3
.subckt NAND_4 A B C D Out VDD GND
  xm3 out B VDD VDD sky130_fd_pr__pfet_01v8 w=1 l=0.15
  xm7 out C VDD VDD sky130_fd_pr__pfet_01v8 w=1 l=0.15
  xm8 out A VDD VDD sky130_fd_pr__pfet_01v8 w=1 l=0.15
  xm9 out D VDD VDD sky130_fd_pr__pfet_01v8 w=1 l=0.15
  xm10 N002 C N003 0 sky130_fd_pr__nfet_01v8 w=0.5 l=0.15
  xm11 N001 B N002 0 sky130_fd_pr__nfet_01v8 w=0.5 l=0.15
  xm12 out A N001 0 sky130_fd_pr__nfet_01v8 w=0.5 l=0.15
  xm13 N003 D GND 0 sky130_fd_pr__nfet_01v8 w=0.5 l=0.15
.ends NAND_4
.subckt delay Inp Inm Outp Outm Vpbias Vrbias VDD GND
  xm1 Outp Vrbias GND 0 sky130_fd_pr__nfet_01v8 w=0.5 l=0.15
  xm4 N001 Vpbias VDD VDD sky130_fd_pr__pfet_01v8 w=10 l=0.15
  xm3 Outp Inm N001 VDD sky130_fd_pr__pfet_01v8 w=1 l=0.15
  xm2 Outp Outp 0 0 sky130_fd_pr__nfet_01v8 w=0.5 l=0.15
  xm5 Outm Inp N001 VDD sky130_fd_pr__pfet_01v8 w=1 l=0.15
  xm6 Outm Vrbias 0 0 sky130_fd_pr__nfet_01v8 w=0.5 l=0.15
  xm7 Outm Outm 0 0 sky130_fd_pr__nfet_01v8 w=0.5 l=0.15
  C1 0 Outp 5f
  C2 Outm 0 5f
.ends delay
.subckt pdiff Inp Inm Out Vpbias VDD GND
  xm4 N001 Vpbias VDD VDD sky130_fd_pr__pfet_01v8 w=10 l=0.15
  xm3 N002 Inp N001 VDD sky130_fd_pr__pfet_01v8 w=1 l=0.15
  xm5 Out Inm N001 VDD sky130_fd_pr__pfet_01v8 w=1 l=0.15
  xm6 N002 N002 GND 0 sky130_fd_pr__nfet_01v8 w=0.5 l=0.15
  xm7 Out N002 0 0 sky130_fd_pr__nfet_01v8 w=0.5 l=0.15
.ends pdiff

.control
tran 1p 100n

let power = v(VDD) * abs(i(VDD))
let avg_power = mean(power)
print avg_power

meas tran vout_max MAX v(out)
meas tran vout_min MIN v(out)
let vout_swing = vout_max - vout_min
print vout_swing

meas tran rise_time TRIG v(out) VAL='0.1*vout_max' RISE=1 TARG v(out) VAL='0.9*vout_max' RISE=1
meas tran fall_time TRIG v(out) VAL='0.9*vout_max' FALL=1 TARG v(out) VAL='0.1*vout_max' FALL=1
print rise_time fall_time

quit
.endc

.end
