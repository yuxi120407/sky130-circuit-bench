* Circuit: Chap27_LTspice/Fig27_27
.lib ${SKY130_PDK} tt

E1 vom N002 vp vm 1e4
E2 N002 vop vp vm 1e4
VCM N002 0 1.5V
R1 vm vom 20000.0
R2 vop vp 20000.0
xm1 N001 N005 vm 0 sky130_fd_pr__nfet_01v8 w=1.47 l=2
xm2 N003 N004 vm 0 sky130_fd_pr__nfet_01v8 w=1.47 l=2
xm3 N001 N004 vp 0 sky130_fd_pr__nfet_01v8 w=1.47 l=2
xm4 N003 N005 vp 0 sky130_fd_pr__nfet_01v8 w=1.47 l=2
Vx N001 N003 0
Vxdc N006 0 DC 1.5 AC 1
Vydc N007 0 0.9
Vy N005 N004 0
R3 N001 N006 20000.0
R4 N003 N006 20000.0
R5 N005 N007 20000.0
R6 N004 N007 20000.0

.control
set filetype=ascii

op
let power_dc = 0
print power_dc

ac dec 100 1 10g
let gain_N003 = db(vm(N003))
let gain_N004 = db(vm(N004))
let gain_vm = db(vm(vm))
let gain_vp = db(vm(vp))
meas ac max_gain_N003 MAX gain_N003
meas ac max_gain_N004 MAX gain_N004
meas ac max_gain_vm MAX gain_vm
meas ac max_gain_vp MAX gain_vp

* Use first probe node for standard metrics
let gain_db = db(vm(N003))
meas ac dc_gain_db FIND gain_db AT=1
meas ac ugbw WHEN gain_db=0 CROSS=1
let vout_dc = v(N003)

print dc_gain_db ugbw vout_dc gain_N003 gain_N004 gain_vm gain_vp

quit
.endc

.end
