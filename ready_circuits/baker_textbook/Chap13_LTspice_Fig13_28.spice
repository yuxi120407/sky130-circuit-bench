* CIRCUIT: Chap13_LTspice/Fig13_28
* YAML: /home/idies/workspace/Storage/xyu1/persistent/ALIGN-public/simple_circuit_5/OpenManus/autosizer_plus/circuits_yaml_generated/Chap13_LTspice__Fig13_28.yaml
* Variables: ['W_nfet_g0', 'W_nfet_g1', 'Cload']
* Trial values (midpoint): [1.47, 1.47, 5e-14]
* Metrics: ['avg_power', 'vout_swing', 'rise_time', 'fall_time', 'fom']
* Class: mosfet_digital_or_small

* Circuit: Chap13_LTspice/Fig13_28
.lib ${SKY130_PDK} tt

xm1 N001 Vin 0 0 sky130_fd_pr__nfet_01v8 w=1.47 l=0.15
VDD VDD 0 1.8
xm2 N001 Vin VDD VDD sky130_fd_pr__pfet_01v8 w=1.47 l=0.15
xm3 Vout N001 0 0 sky130_fd_pr__nfet_01v8 w=1.47 l=0.15
xm4 Vout N001 VDD VDD sky130_fd_pr__pfet_01v8 w=1.47 l=0.15
Cload Vout 0 5e-14
V1 Vin 0 PULSE(0 1.8 500p 1p 1p 500p 6n)

.control
tran 1p 100n

let power = v(VDD) * abs(i(VDD))
let avg_power = mean(power)
print avg_power

meas tran vout_max MAX v(vout)
meas tran vout_min MIN v(vout)
let vout_swing = vout_max - vout_min
print vout_swing

meas tran rise_time TRIG v(vout) VAL='0.1*vout_max' RISE=1 TARG v(vout) VAL='0.9*vout_max' RISE=1
meas tran fall_time TRIG v(vout) VAL='0.9*vout_max' FALL=1 TARG v(vout) VAL='0.1*vout_max' FALL=1
print rise_time fall_time

quit
.endc

.end
