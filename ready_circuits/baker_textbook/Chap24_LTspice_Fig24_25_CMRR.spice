* Circuit: Chap24_LTspice/Fig24_25_CMRR
.lib ${SKY130_PDK} tt

VDD VDD 0 1.8
xm2 N002 vp1 N004 0 sky130_fd_pr__nfet_01v8 w=1.47 l=0.15
xm1 N001 vm1 N004 0 sky130_fd_pr__nfet_01v8 w=1.47 l=0.15
xm4 N002 N001 VDD VDD sky130_fd_pr__pfet_01v8 w=1.47 l=0.15
xm3 N001 N001 VDD VDD sky130_fd_pr__pfet_01v8 w=1.47 l=0.15
X_U1 Vbias1 Vhigh Vbias2 Vpcas Vncas Vbias3 Vlow Vbias4 VDD 0 Fig_20_47
xm6t N004 Vbias3 N005 0 sky130_fd_pr__nfet_01v8 w=1.47 l=0.15
xm6b N005 Vbias4 0 0 sky130_fd_pr__nfet_01v8 w=1.47 l=0.15
vp vp1 0 500m AC 1
xm7 Ad N002 VDD VDD sky130_fd_pr__pfet_01v8 w=1.47 l=0.15
xm8t Ad Vbias3 N006 0 sky130_fd_pr__nfet_01v8 w=1.47 l=0.15
xm8b N006 Vbias4 0 0 sky130_fd_pr__nfet_01v8 w=1.47 l=0.15
C1 vm1 0 1e-05
R1 vm1 Ad 100000000.0
Cc Ad N003 2.4e-12
C3 Ad 0 1e-13
Rz N002 N003 6500.0
xm5 N008 vp1 N011 0 sky130_fd_pr__nfet_01v8 w=1.47 l=0.15
xm6 N007 N009 N011 0 sky130_fd_pr__nfet_01v8 w=1.47 l=0.15
xm8 N008 N007 VDD VDD sky130_fd_pr__pfet_01v8 w=1.47 l=0.15
xm9 N007 N007 VDD VDD sky130_fd_pr__pfet_01v8 w=1.47 l=0.15
xm10 N011 Vbias3 N012 0 sky130_fd_pr__nfet_01v8 w=1.47 l=0.15
xm11 N012 Vbias4 0 0 sky130_fd_pr__nfet_01v8 w=1.47 l=0.15
xm12 Ac N008 VDD VDD sky130_fd_pr__pfet_01v8 w=1.47 l=0.15
xm13 Ac Vbias3 N013 0 sky130_fd_pr__nfet_01v8 w=1.47 l=0.15
xm14 N013 Vbias4 0 0 sky130_fd_pr__nfet_01v8 w=1.47 l=0.15
R2 N009 Ac 100000000.0
Cc1 Ac N010 2.4e-12
C4 Ac 0 1e-13
Rz1 N008 N010 6500.0
C2 vp1 N009 1e-05
.subckt Fig_20_47 Vbias1 Vhigh Vbias2 Vpcas Vncas Vbias3 Vlow Vbias4 VDD GND
  xmsu2 N002 N002 VDD VDD sky130_fd_pr__pfet_01v8 w=1 l=0.15
  xmsu1 N002 N003 0 0 sky130_fd_pr__nfet_01v8 w=1 l=0.15
  xmsu3 Vbiasp N002 N003 0 sky130_fd_pr__nfet_01v8 w=1 l=0.15
  xm3 N003 Vbiasp VDD VDD sky130_fd_pr__pfet_01v8 w=5 l=0.15
  xm4 N004 Vbiasp VDD VDD sky130_fd_pr__pfet_01v8 w=5 l=0.15
  xm1 N003 N003 0 0 sky130_fd_pr__nfet_01v8 w=1 l=0.15
  xm2 N004 N004 N005 0 sky130_fd_pr__nfet_01v8 w=1 l=0.15
  R1 N005 GND 5.5k
  xma4 Vbiasp N001 VDD VDD sky130_fd_pr__pfet_01v8 w=5 l=0.15
  xma3 N001 N001 VDD VDD sky130_fd_pr__pfet_01v8 w=5 l=0.15
  xm5 N001 N004 0 0 sky130_fd_pr__nfet_01v8 w=1 l=0.15
  xm6 Vbiasp N003 0 0 sky130_fd_pr__nfet_01v8 w=1 l=0.15
  xm7 VDD Vbiasp VDD VDD sky130_fd_pr__pfet_01v8 w=5 l=5
  xma1 Vbias3 Vbiasp VDD VDD sky130_fd_pr__pfet_01v8 w=5 l=0.15
  xma2 Vbias4 Vbiasp VDD VDD sky130_fd_pr__pfet_01v8 w=5 l=0.15
  xmsu4 Vbias3 Vbias3 0 0 sky130_fd_pr__nfet_01v8 w=0.5 l=0.5
  xm8 Vbias4 Vbias3 Vlow 0 sky130_fd_pr__nfet_01v8 w=1 l=0.15
  xm9 Vlow Vbias4 0 0 sky130_fd_pr__nfet_01v8 w=1 l=0.15
  xm10 Vpcas Vbias3 N009 0 sky130_fd_pr__nfet_01v8 w=1 l=0.15
  xm11 N009 Vbias4 0 0 sky130_fd_pr__nfet_01v8 w=1 l=0.15
  xm12 Vbias2 Vbias3 N010 0 sky130_fd_pr__nfet_01v8 w=1 l=0.15
  xm13 N010 Vbias4 0 0 sky130_fd_pr__nfet_01v8 w=1 l=0.15
  xm14 Vbias1 Vbias3 N011 0 sky130_fd_pr__nfet_01v8 w=1 l=0.15
  xm15 N011 Vbias4 0 0 sky130_fd_pr__nfet_01v8 w=1 l=0.15
  xma5 Vpcas Vpcas N006 VDD sky130_fd_pr__pfet_01v8 w=5 l=0.15
  xma6 N006 Vbias2 N007 VDD sky130_fd_pr__pfet_01v8 w=5 l=0.15
  xma7 N007 N006 VDD VDD sky130_fd_pr__pfet_01v8 w=5 l=0.15
  xma8 Vbias2 Vbias2 VDD VDD sky130_fd_pr__pfet_01v8 w=1 l=0.5
  xma9 Vbias1 Vbias2 Vhigh VDD sky130_fd_pr__pfet_01v8 w=5 l=0.15
  xma10 Vhigh Vbias1 VDD VDD sky130_fd_pr__pfet_01v8 w=5 l=0.15
  xma11 Vncas Vbias2 N008 VDD sky130_fd_pr__pfet_01v8 w=5 l=0.15
  xma12 N008 Vbias1 VDD VDD sky130_fd_pr__pfet_01v8 w=5 l=0.15
  xm16 Vncas Vncas N012 0 sky130_fd_pr__nfet_01v8 w=1 l=0.15
  xm17 N012 Vbias3 P001 0 sky130_fd_pr__nfet_01v8 w=1 l=0.15
  xm18 P001 N012 0 0 sky130_fd_pr__nfet_01v8 w=1 l=0.15
.ends Fig_20_47

.control
op
let vdd_current = abs(i(VDD))
let power_dc = vdd_current * 1.8
print power_dc

ac dec 100 1 10g
let vout_mag = vm(vm1)
let gain_db = db(vout_mag)
let dc_gain_db = gain_db[0]
print dc_gain_db

if dc_gain_db > 0
    meas ac ugbw WHEN gain_db=0 CROSS=1
end

quit
.endc

.end
