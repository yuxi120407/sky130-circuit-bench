* CIRCUIT: Chap17_LTspice_Fig17_6
* YAML: /home/idies/workspace/Storage/xyu1/persistent/ALIGN-public/simple_circuit_5/OpenManus/autosizer_plus/circuits_yaml_generated/Chap17_LTspice__Fig17_6.yaml
* Variables: ['W_nfet_g0', 'Cbit']
* Trial values (midpoint): [1.47, 5e-13]
* Metrics: ['avg_power', 'vout_swing', 'rise_time', 'fall_time', 'fom']
* Class: mosfet_analog_tran
* FOM: 8.416304080705711e-11
* FIXED: node rename {'vout': 'out'}

* Circuit: Chap17_LTspice/Fig17_6
.lib ${SKY130_PDK} tt

VDD VDD 0 1.8
xm3 0 0 N003 VDD sky130_fd_pr__pfet_01v8 w=1.47 l=0.15
xm1 vbit Outi N002 VDD sky130_fd_pr__pfet_01v8 w=1.47 l=0.15
VREF VREF 0 500m
Vclock clock 0 PULSE(1.8 0 6n 10p 10p 4n 10n)
Cbit vbit 0 5e-13
X_U1 vbit VREF Outi Out clock VDD 0 Fig_17_16_no_Vos
I1 vbit 0 1µ
xm2 N003 Out N002 VDD sky130_fd_pr__pfet_01v8 w=1.47 l=0.15
Ibias N001 0 10µ
xm4 N002 N001 VDD VDD sky130_fd_pr__pfet_01v8 w=1.47 l=0.15
xm5 N001 N001 VDD VDD sky130_fd_pr__pfet_01v8 w=1.47 l=0.15
.subckt Fig_17_16_no_Vos inp inm q qi clock VDD GND
  xm1 N003 inp GND 0 sky130_fd_pr__nfet_01v8 w=0.5 l=0.15
  xm2 Outm Outp VDD VDD sky130_fd_pr__pfet_01v8 w=1 l=0.15
  xm3 Outp Outm VDD VDD sky130_fd_pr__pfet_01v8 w=1 l=0.15
  xm5 N002 Outm N004 0 sky130_fd_pr__nfet_01v8 w=0.5 l=0.15
  xm6 N001 Outp N003 0 sky130_fd_pr__nfet_01v8 w=0.5 l=0.15
  xm4 Outm clock VDD VDD sky130_fd_pr__pfet_01v8 w=1 l=0.15
  xm7 Outp clock VDD VDD sky130_fd_pr__pfet_01v8 w=1 l=0.15
  xm8 Outm clock N001 0 sky130_fd_pr__nfet_01v8 w=0.5 l=0.15
  xm9 Outp clock N002 0 sky130_fd_pr__nfet_01v8 w=0.5 l=0.15
  xm10 N004 inm 0 0 sky130_fd_pr__nfet_01v8 w=0.5 l=0.15
  X_U1 Outp q qi VDD 0 NAND_2
  X_U2 qi Outm q VDD 0 NAND_2
.ends Fig_17_16_no_Vos
.subckt NAND_2 A B Out VDD GND
  xm3 out B VDD VDD sky130_fd_pr__pfet_01v8 w=1 l=0.15
  xm8 out A VDD VDD sky130_fd_pr__pfet_01v8 w=1 l=0.15
  xm11 N001 B GND 0 sky130_fd_pr__nfet_01v8 w=0.5 l=0.15
  xm12 out A N001 0 sky130_fd_pr__nfet_01v8 w=0.5 l=0.15
.ends NAND_2

.control
tran 1p 100n

let power = v(VDD) * abs(i(VDD))
let avg_power = mean(power)
print avg_power

meas tran vout_max MAX v(out)
meas tran vout_min MIN v(out)
let vout_swing = vout_max - vout_min
print vout_swing

meas tran rise_time TRIG v(out) VAL='0.1*vout_max' RISE=1 TARG v(out) VAL='0.9*vout_max' RISE=1
meas tran fall_time TRIG v(out) VAL='0.9*vout_max' FALL=1 TARG v(out) VAL='0.1*vout_max' FALL=1
print rise_time fall_time

quit
.endc

.end
