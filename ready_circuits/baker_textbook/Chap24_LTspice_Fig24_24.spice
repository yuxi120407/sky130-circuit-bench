* CIRCUIT: Chap24_LTspice/Fig24_24
* YAML: /home/idies/workspace/Storage/xyu1/persistent/ALIGN-public/simple_circuit_5/OpenManus/autosizer_plus/circuits_yaml_generated/Chap24_LTspice__Fig24_24.yaml
* Variables: ['W_nfet_g0', 'W_nfet_g1', 'W_nfet_g2', 'Cc', 'C3']
* Trial values (midpoint): [1.47, 1.47, 1.47, 2.4e-13, 1e-12]
* Metrics: ['avg_power', 'vout_swing', 'rise_time', 'fall_time', 'fom']
* Class: mosfet_analog_tran

* Circuit: Chap24_LTspice/Fig24_24
.lib ${SKY130_PDK} tt

VDD VDD 0 1.8
xm2 N002 vin N006 0 sky130_fd_pr__nfet_01v8 w=1.47 l=0.15
xm1 N001 vout N006 0 sky130_fd_pr__nfet_01v8 w=1.47 l=0.15
xm4t N003 N001 VDD VDD sky130_fd_pr__pfet_01v8 w=1.47 l=0.15
xm3t N004 N001 VDD VDD sky130_fd_pr__pfet_01v8 w=1.47 l=0.15
X_U1 Vbias1 Vhigh Vbias2 Vpcas Vncas Vbias3 Vlow Vbias4 VDD 0 Fig_20_47
xm6t N006 Vbias3 N007 0 sky130_fd_pr__nfet_01v8 w=1.47 l=0.15
xm6b N007 Vbias4 0 0 sky130_fd_pr__nfet_01v8 w=1.47 l=0.15
vp vin 0 PULSE(500m 900m 500n 100p 100p 50n 2u) AC 0
xm7b vout N002 N005 VDD sky130_fd_pr__pfet_01v8 w=1.47 l=0.15
xm8t vout Vbias3 N008 0 sky130_fd_pr__nfet_01v8 w=1.47 l=0.15
xm8b N008 Vbias4 0 0 sky130_fd_pr__nfet_01v8 w=1.47 l=0.15
Cc vout N003 2.4e-13
C3 vout 0 1e-12
xm4b N002 N001 N003 VDD sky130_fd_pr__pfet_01v8 w=1.47 l=0.15
xm3b N001 N001 N004 VDD sky130_fd_pr__pfet_01v8 w=1.47 l=0.15
xm7t N005 N002 VDD VDD sky130_fd_pr__pfet_01v8 w=1.47 l=0.15
.subckt Fig_20_47 Vbias1 Vhigh Vbias2 Vpcas Vncas Vbias3 Vlow Vbias4 VDD GND
  xmsu2 N002 N002 VDD VDD sky130_fd_pr__pfet_01v8 w=1 l=0.15
  xmsu1 N002 N003 0 0 sky130_fd_pr__nfet_01v8 w=1 l=0.15
  xmsu3 Vbiasp N002 N003 0 sky130_fd_pr__nfet_01v8 w=1 l=0.15
  xm3 N003 Vbiasp VDD VDD sky130_fd_pr__pfet_01v8 w=5 l=0.15
  xm4 N004 Vbiasp VDD VDD sky130_fd_pr__pfet_01v8 w=5 l=0.15
  xm1 N003 N003 0 0 sky130_fd_pr__nfet_01v8 w=1 l=0.15
  xm2 N004 N004 N005 0 sky130_fd_pr__nfet_01v8 w=1 l=0.15
  R1 N005 GND 5.5k
  xma4 Vbiasp N001 VDD VDD sky130_fd_pr__pfet_01v8 w=5 l=0.15
  xma3 N001 N001 VDD VDD sky130_fd_pr__pfet_01v8 w=5 l=0.15
  xm5 N001 N004 0 0 sky130_fd_pr__nfet_01v8 w=1 l=0.15
  xm6 Vbiasp N003 0 0 sky130_fd_pr__nfet_01v8 w=1 l=0.15
  xm7 VDD Vbiasp VDD VDD sky130_fd_pr__pfet_01v8 w=5 l=5
  xma1 Vbias3 Vbiasp VDD VDD sky130_fd_pr__pfet_01v8 w=5 l=0.15
  xma2 Vbias4 Vbiasp VDD VDD sky130_fd_pr__pfet_01v8 w=5 l=0.15
  xmsu4 Vbias3 Vbias3 0 0 sky130_fd_pr__nfet_01v8 w=0.5 l=0.5
  xm8 Vbias4 Vbias3 Vlow 0 sky130_fd_pr__nfet_01v8 w=1 l=0.15
  xm9 Vlow Vbias4 0 0 sky130_fd_pr__nfet_01v8 w=1 l=0.15
  xm10 Vpcas Vbias3 N009 0 sky130_fd_pr__nfet_01v8 w=1 l=0.15
  xm11 N009 Vbias4 0 0 sky130_fd_pr__nfet_01v8 w=1 l=0.15
  xm12 Vbias2 Vbias3 N010 0 sky130_fd_pr__nfet_01v8 w=1 l=0.15
  xm13 N010 Vbias4 0 0 sky130_fd_pr__nfet_01v8 w=1 l=0.15
  xm14 Vbias1 Vbias3 N011 0 sky130_fd_pr__nfet_01v8 w=1 l=0.15
  xm15 N011 Vbias4 0 0 sky130_fd_pr__nfet_01v8 w=1 l=0.15
  xma5 Vpcas Vpcas N006 VDD sky130_fd_pr__pfet_01v8 w=5 l=0.15
  xma6 N006 Vbias2 N007 VDD sky130_fd_pr__pfet_01v8 w=5 l=0.15
  xma7 N007 N006 VDD VDD sky130_fd_pr__pfet_01v8 w=5 l=0.15
  xma8 Vbias2 Vbias2 VDD VDD sky130_fd_pr__pfet_01v8 w=1 l=0.5
  xma9 Vbias1 Vbias2 Vhigh VDD sky130_fd_pr__pfet_01v8 w=5 l=0.15
  xma10 Vhigh Vbias1 VDD VDD sky130_fd_pr__pfet_01v8 w=5 l=0.15
  xma11 Vncas Vbias2 N008 VDD sky130_fd_pr__pfet_01v8 w=5 l=0.15
  xma12 N008 Vbias1 VDD VDD sky130_fd_pr__pfet_01v8 w=5 l=0.15
  xm16 Vncas Vncas N012 0 sky130_fd_pr__nfet_01v8 w=1 l=0.15
  xm17 N012 Vbias3 P001 0 sky130_fd_pr__nfet_01v8 w=1 l=0.15
  xm18 P001 N012 0 0 sky130_fd_pr__nfet_01v8 w=1 l=0.15
.ends Fig_20_47

.control
tran 1p 100n

let power = v(VDD) * abs(i(VDD))
let avg_power = mean(power)
print avg_power

meas tran vout_max MAX v(vout)
meas tran vout_min MIN v(vout)
let vout_swing = vout_max - vout_min
print vout_swing

meas tran rise_time TRIG v(vout) VAL='0.1*vout_max' RISE=1 TARG v(vout) VAL='0.9*vout_max' RISE=1
meas tran fall_time TRIG v(vout) VAL='0.9*vout_max' FALL=1 TARG v(vout) VAL='0.1*vout_max' FALL=1
print rise_time fall_time

quit
.endc

.end
