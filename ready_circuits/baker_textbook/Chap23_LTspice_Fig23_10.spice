* Circuit: Chap23_LTspice/Fig23_10
.lib ${SKY130_PDK} tt

VDD VDD 0 1.8
xmsu1 N002 Vbiasn 0 0 sky130_fd_pr__nfet_01v8 w=1.47 l=0.15
xmsu3 Vbiasp N002 Vbiasn 0 sky130_fd_pr__nfet_01v8 w=1.47 l=0.15
xmsu2 N002 N002 VDD VDD sky130_fd_pr__pfet_01v8 w=1.47 l=1
xm3t N001 Vbiasp VDD VDD sky130_fd_pr__pfet_01v8 w=1.47 l=0.15
xm3b Vbiasn Vpcas N001 VDD sky130_fd_pr__pfet_01v8 w=1.47 l=0.15
xm4t Vbiasp Vbiasp VDD VDD sky130_fd_pr__pfet_01v8 w=1.47 l=0.15
xm4b Vpcas Vpcas Vbiasp VDD sky130_fd_pr__pfet_01v8 w=1.47 l=0.15
xm2 Vpcas Vbiasn N003 0 sky130_fd_pr__nfet_01v8 w=1.47 l=0.15
xm1 Vbiasn Vbiasn 0 0 sky130_fd_pr__nfet_01v8 w=1.47 l=0.15
R1 N003 0 6500.0

.control
set filetype=ascii

op
let power_dc = abs(i(VDD)) * 1.8
let vout_dc = v(Vbiasp)
print power_dc vout_dc

quit
.endc

.end
