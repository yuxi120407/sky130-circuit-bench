* Circuit: Chap20_LTspice/Fig20_13
.lib ${SKY130_PDK} tt

xm4p 0 N001 VDD VDD sky130_fd_pr__pfet_01v8 w=1.47 l=2
xm3n N001 N001 VDD VDD sky130_fd_pr__pfet_01v8 w=1.47 l=2
VDD VDD 0 1.8
xm1n N001 N001 0 0 sky130_fd_pr__nfet_01v8 w=1.47 l=20
xm3p N002 N002 VDD VDD sky130_fd_pr__pfet_01v8 w=1.47 l=20
xm1p N002 N002 0 0 sky130_fd_pr__nfet_01v8 w=1.47 l=2
xm2n VDD N002 0 0 sky130_fd_pr__nfet_01v8 w=1.47 l=2

.control
set filetype=ascii

op
let vdd_current = abs(i(VDD))
let power_dc = vdd_current * 1.8
let vnode_N001 = v(N001)
let vnode_N002 = v(N002)
let vout_dc = vnode_N001
print power_dc vout_dc vnode_N001 vnode_N002

let vout_dc = v(N002)
print vout_dc
let vout_dc = v(N001)
print vout_dc
quit
.endc

.end
