* Circuit: Chap20_LTspice/Fig20_4
.lib ${SKY130_PDK} tt

xm2 N002 N003 0 0 sky130_fd_pr__nfet_01v8 w=1.47 l=2
VDD N001 0 1.8
xm1 N003 N003 0 0 sky130_fd_pr__nfet_01v8 w=1.47 l=2
R1 N001 N003 200000.0
Vo N002 0 0

.control
dc Vo 0 1.8 0.0018

let iout = abs(i(Vo))
let iout_deriv = deriv(iout)
let rout = 1.0 / abs(iout_deriv)

meas dc iout_mid FIND iout AT=0.9
meas dc rout_mid FIND rout AT=0.9

let vdd_current = abs(i(VDD))
let power_dc = mean(vdd_current) * 1.8
print iout_mid rout_mid power_dc

quit
.endc

.end
