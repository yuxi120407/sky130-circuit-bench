* Voltage-Controlled Oscillator
.lib ${SKY130_PDK} tt
.global VDD GND

* Stage 0 (10% weaker PMOS for symmetry breaking)
XMPINV0 N1 N0 VDD VDD sky130_fd_pr__pfet_01v8 l=0.75 w=3.6 m=1
XMNINV0 N1 N0 0 0 sky130_fd_pr__nfet_01v8 l=0.75 w=4.0 m=1

* Stage 1
XMPINV1 N2 N1 VDD VDD sky130_fd_pr__pfet_01v8 l=0.75 w=4.0 m=1
XMNINV1 N2 N1 0 0 sky130_fd_pr__nfet_01v8 l=0.75 w=4.0 m=1

* Stage 2
XMPINV2 N3 N2 VDD VDD sky130_fd_pr__pfet_01v8 l=0.75 w=4.0 m=1
XMNINV2 N3 N2 0 0 sky130_fd_pr__nfet_01v8 l=0.75 w=4.0 m=1

* Stage 3
XMPINV3 N4 N3 VDD VDD sky130_fd_pr__pfet_01v8 l=0.75 w=4.0 m=1
XMNINV3 N4 N3 0 0 sky130_fd_pr__nfet_01v8 l=0.75 w=4.0 m=1

* Stage 4
XMPINV4 N0 N4 VDD VDD sky130_fd_pr__pfet_01v8 l=0.75 w=4.0 m=1
XMNINV4 N0 N4 0 0 sky130_fd_pr__nfet_01v8 l=0.75 w=4.0 m=1

* Load capacitors
C0 N0 0 5.5e-14
C1 N1 0 5.5e-14
C2 N2 0 5.5e-14
C3 N3 0 5.5e-14
C4 N4 0 5.5e-14

* Power supply
VSUP VDD 0 PWL(0 0 10n 1.8)

* Symmetry breaking
RBREAK N0 0 10G

.ic v(N0)=1.8

.control
tran 0.1n 200n

meas tran v_first WHEN v(N3)=0.9 RISE=2
meas tran v_second WHEN v(N3)=0.9 RISE=3
let period = v_second - v_first
let freq = 1/period
print period freq

let i_avg = mean(abs(i(VSUP)))
let power_avg = 1.8 * i_avg
print i_avg power_avg

quit
.endc

.end
