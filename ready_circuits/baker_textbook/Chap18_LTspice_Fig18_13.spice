* CIRCUIT: Chap18_LTspice/Fig18_13
* YAML: /home/idies/workspace/Storage/xyu1/persistent/ALIGN-public/simple_circuit_5/OpenManus/autosizer_plus/circuits_yaml_generated/Chap18_LTspice__Fig18_13.yaml
* Variables: ['W_nfet_g0', 'W_nfet_g1', 'C1']
* Trial values (midpoint): [1.47, 1.47, 1e-13]
* Metrics: ['avg_power', 'vout_swing', 'rise_time', 'fall_time', 'fom']
* Class: mosfet_digital_or_small

* Circuit: Chap18_LTspice/Fig18_13
.lib ${SKY130_PDK} tt

xm1 Vout Vin 0 0 sky130_fd_pr__nfet_01v8 w=1.47 l=0.15
Vin Vin 0 PULSE(0 1.8 1n 1n 1n 0.5n)
VDD VDD 0 1.8
xm2 Vout Vin VDD VDD sky130_fd_pr__pfet_01v8 w=1.47 l=0.15
C1 Vout 0 1e-13
xm3 Vout2 Vout 0 0 sky130_fd_pr__nfet_01v8 w=1.47 l=0.15
xm4 Vout2 Vout VDD VDD sky130_fd_pr__pfet_01v8 w=1.47 l=0.15

.control
tran 1p 100n

let power = v(VDD) * abs(i(VDD))
let avg_power = mean(power)
print avg_power

meas tran vout_max MAX v(vout)
meas tran vout_min MIN v(vout)
let vout_swing = vout_max - vout_min
print vout_swing

meas tran rise_time TRIG v(vout) VAL='0.1*vout_max' RISE=1 TARG v(vout) VAL='0.9*vout_max' RISE=1
meas tran fall_time TRIG v(vout) VAL='0.9*vout_max' FALL=1 TARG v(vout) VAL='0.1*vout_max' FALL=1
print rise_time fall_time

quit
.endc

.end
