* CIRCUIT: Chap26_LTspice_Fig26_59
* YAML: /home/idies/workspace/Storage/xyu1/persistent/ALIGN-public/simple_circuit_5/OpenManus/autosizer_plus/circuits_yaml_generated/Chap26_LTspice__Fig26_59.yaml
* Variables: ['W_nfet_g0', 'W_nfet_g1', 'W_nfet_g2', 'W_nfet_g3', 'W_nfet_g4', 'C1', 'C2', 'C3', 'C4', 'C5', 'C6']
* Trial values (midpoint): [1.47, 1.47, 1.47, 1.47, 1.47, 5e-14, 5e-14, 2.5e-13, 2.5e-13, 2.5e-13, 2.5e-13]
* Metrics: ['avg_power', 'vout_swing', 'rise_time', 'fall_time', 'fom']
* Class: mosfet_analog_tran
* FOM: 4.7182528142148084e-12
* FIXED: node rename {'vout': 'voutm'}

* Circuit: Chap26_LTspice/Fig26_59
.lib ${SKY130_PDK} tt

VDD VDD 0 1.8
xm2 vomd Vbias1 N011 0 sky130_fd_pr__nfet_01v8 w=1.47 l=0.15
xm3 Vbias1 Vbias2 N003 VDD sky130_fd_pr__pfet_01v8 w=1.47 l=0.15
VCM VCM 0 500m
X_U1 Vbiasn Vbiasp VDD 0 Fig_26_3
xm6 N001 Vbias1 VDD VDD sky130_fd_pr__pfet_01v8 w=1.47 l=0.15
xm9 N003 Vbias1 VDD VDD sky130_fd_pr__pfet_01v8 w=1.47 l=0.15
xm10 Vbias2 Vbias2 VDD VDD sky130_fd_pr__pfet_01v8 w=1.47 l=0.15
xm13 Vbias1 Vbias1 N006 0 sky130_fd_pr__nfet_01v8 w=1.47 l=0.15
xm5 N010 Vbiasn 0 0 sky130_fd_pr__nfet_01v8 w=1.47 l=0.15
xm16 N009 Vbiasn 0 0 sky130_fd_pr__nfet_01v8 w=1.47 l=0.15
xm18 N006 VCM N009 0 sky130_fd_pr__nfet_01v8 w=1.47 l=0.15
xm19 Vbias2 VCM N010 0 sky130_fd_pr__nfet_01v8 w=1.47 l=0.15
xm1 N002 Vbias1 VDD VDD sky130_fd_pr__pfet_01v8 w=1.47 l=0.15
xm4 vomd Vbias2 N001 VDD sky130_fd_pr__pfet_01v8 w=1.47 l=0.15
xm7 vopd Vbias2 N002 VDD sky130_fd_pr__pfet_01v8 w=1.47 l=0.15
xm8 vopd Vbias1 N012 0 sky130_fd_pr__nfet_01v8 w=1.47 l=0.15
xm11 N011 vp N014 0 sky130_fd_pr__nfet_01v8 w=1.47 l=0.15
xm12 N012 vm N014 0 sky130_fd_pr__nfet_01v8 w=1.47 l=0.15
xm14 N014 Vbiasn 0 0 sky130_fd_pr__nfet_01v8 w=1.47 l=0.15
xm15 N014 VCMFB1 0 0 sky130_fd_pr__nfet_01v8 w=1.47 l=0.15
xm17 vomd phi1b vopd VDD sky130_fd_pr__pfet_01v8 w=1.47 l=0.15
xm20 vomd phi1 vopd 0 sky130_fd_pr__nfet_01v8 w=1.47 l=0.15
X_X1 Vbiasn Vbias1 vopd vomd phi1 phi1b phi2 phi2b VCMFB1 VDD 0 Fig_26_50
xm21 vp phi1b VCM VDD sky130_fd_pr__pfet_01v8 w=1.47 l=0.15
xm22 vp phi1 VCM 0 sky130_fd_pr__nfet_01v8 w=1.47 l=0.15
xm23 vm phi1b VCM VDD sky130_fd_pr__pfet_01v8 w=1.47 l=0.15
xm24 vm phi1 VCM 0 sky130_fd_pr__nfet_01v8 w=1.47 l=0.15
C1 N011 vop 5e-14
C2 vom N012 5e-14
xm25 vom vopd VDD VDD sky130_fd_pr__pfet_01v8 w=1.47 l=0.15
xm26 N004 vomd VDD VDD sky130_fd_pr__pfet_01v8 w=1.47 l=0.15
xm27 vom N004 N013 0 sky130_fd_pr__nfet_01v8 w=1.47 l=0.15
xm28 N004 N004 N008 0 sky130_fd_pr__nfet_01v8 w=1.47 l=0.15
xm29 vop vomd VDD VDD sky130_fd_pr__pfet_01v8 w=1.47 l=0.15
xm30 N005 vopd VDD VDD sky130_fd_pr__pfet_01v8 w=1.47 l=0.15
xm31 vop N005 N013 0 sky130_fd_pr__nfet_01v8 w=1.47 l=0.15
xm32 N005 N005 N007 0 sky130_fd_pr__nfet_01v8 w=1.47 l=0.15
xm33 N013 VCMFB2 0 0 sky130_fd_pr__nfet_01v8 w=1.47 l=0.15
xm34 N013 VCMFB2 0 0 sky130_fd_pr__nfet_01v8 w=1.47 l=0.15
xm35 N007 VCM 0 0 sky130_fd_pr__nfet_01v8 w=1.47 l=0.15
xm36 N008 VCM 0 0 sky130_fd_pr__nfet_01v8 w=1.47 l=0.15
xm37 vop phi1b vom VDD sky130_fd_pr__pfet_01v8 w=1.47 l=0.15
xm38 vop phi1 vom 0 sky130_fd_pr__nfet_01v8 w=1.47 l=0.15
X_X2 VCM VCM vop vom phi1 phi1b phi2 phi2b VCMFB2 VDD 0 Fig_26_50
xm39 vinp phi1b N015 VDD sky130_fd_pr__pfet_01v8 w=1.47 l=0.15
xm40 vinp phi1 N015 0 sky130_fd_pr__nfet_01v8 w=1.47 l=0.15
Vinp vinp 0 SIN 500m 300m .5MEG
C3 vm N015 2.5e-13
xm41 N015 phi2b Vop VDD sky130_fd_pr__pfet_01v8 w=1.47 l=0.15
xm42 N015 phi2 Vop 0 sky130_fd_pr__nfet_01v8 w=1.47 l=0.15
xm43 vinm phi1b N016 VDD sky130_fd_pr__pfet_01v8 w=1.47 l=0.15
xm44 vinm phi1 N016 0 sky130_fd_pr__nfet_01v8 w=1.47 l=0.15
Vinm vinm 0 SIN 500m -300m .5MEG
C4 vp N016 2.5e-13
xm45 N016 phi2b Vom VDD sky130_fd_pr__pfet_01v8 w=1.47 l=0.15
xm46 N016 phi2 Vom 0 sky130_fd_pr__nfet_01v8 w=1.47 l=0.15
xm47 Vop phi2b Voutp VDD sky130_fd_pr__pfet_01v8 w=1.47 l=0.15
xm48 Vop phi2 Voutp 0 sky130_fd_pr__nfet_01v8 w=1.47 l=0.15
xm49 Vom phi2b Voutm VDD sky130_fd_pr__pfet_01v8 w=1.47 l=0.15
xm50 Vom phi2 Voutm 0 sky130_fd_pr__nfet_01v8 w=1.47 l=0.15
C5 Voutp 0 2.5e-13
C6 Voutm 0 2.5e-13
Vphi1 phi1 0 Pulse 0 1 0 100p 100p 49n 100n
Vphi2 phi1b 0 Pulse 1 0 0 100p 100p 49n 100n
Vphi3 phi2 0 Pulse 0 1 50n 100p 100p 49n 100n
Vphi4 phi2b 0 Pulse 1 0 50n 100p 100p 49n 100n
.subckt Fig_26_3 Vbiasn Vbiasp VDD GND
  xmsu2 N002 N002 VDD VDD sky130_fd_pr__pfet_01v8 w=1 l=0.15
  xmsu1 N002 Vbiasn GND 0 sky130_fd_pr__nfet_01v8 w=0.5 l=0.15
  xmsu3 Vbiasp N002 Vbiasn 0 sky130_fd_pr__nfet_01v8 w=1 l=0.15
  xm3 Vbiasn Vbiasp VDD VDD sky130_fd_pr__pfet_01v8 w=1 l=0.15
  xm4 N003 Vbiasp VDD VDD sky130_fd_pr__pfet_01v8 w=1 l=0.15
  xm1 Vbiasn Vbiasn 0 0 sky130_fd_pr__nfet_01v8 w=0.5 l=0.15
  R1 N004 0 4k
  xma4 Vbiasp N001 VDD VDD sky130_fd_pr__pfet_01v8 w=1 l=0.15
  xma3 N001 N001 VDD VDD sky130_fd_pr__pfet_01v8 w=1 l=0.15
  xm5 N001 N003 0 0 sky130_fd_pr__nfet_01v8 w=0.5 l=0.15
  xm7 VDD Vbiasp VDD VDD sky130_fd_pr__pfet_01v8 w=5 l=5
  xm2 Vbiasp Vbiasn 0 0 sky130_fd_pr__nfet_01v8 w=0.5 l=0.15
  xm6 N003 N003 N004 0 sky130_fd_pr__nfet_01v8 w=2 l=0.15
.ends Fig_26_3
.subckt Fig_26_50 ideal_vcmfb ideal_vcma Vop Vom phi1 phi1b phi2 phi2b VCMFB VDD GND
  xm1 ideal_vcma phi1 N001 GND sky130_fd_pr__nfet_01v8 w=0.5 l=0.15
  xm2 N001 phi1b ideal_vcma VDD sky130_fd_pr__pfet_01v8 w=0.5 l=0.15
  xm3 N001 phi2 vop 0 sky130_fd_pr__nfet_01v8 w=0.5 l=0.15
  xm4 vop phi2b N001 VDD sky130_fd_pr__pfet_01v8 w=0.5 l=0.15
  xm5 ideal_vcmfb phi1 N003 0 sky130_fd_pr__nfet_01v8 w=0.5 l=0.15
  xm6 N003 phi1b ideal_vcmfb VDD sky130_fd_pr__pfet_01v8 w=0.5 l=0.15
  xm7 N003 phi2 VCMFB 0 sky130_fd_pr__nfet_01v8 w=0.5 l=0.15
  xm8 VCMFB phi2b N003 VDD sky130_fd_pr__pfet_01v8 w=0.5 l=0.15
  C1 N001 N003 50f
  C2 vop VCMFB 10f
  xm9 ideal_vcma phi1 N002 0 sky130_fd_pr__nfet_01v8 w=0.5 l=0.15
  xm10 N002 phi1b ideal_vcma VDD sky130_fd_pr__pfet_01v8 w=0.5 l=0.15
  xm11 N002 phi2 vom 0 sky130_fd_pr__nfet_01v8 w=0.5 l=0.15
  xm12 vom phi2b N002 VDD sky130_fd_pr__pfet_01v8 w=0.5 l=0.15
  xm13 ideal_vcmfb phi1 N004 0 sky130_fd_pr__nfet_01v8 w=0.5 l=0.15
  xm14 N004 phi1b ideal_vcmfb VDD sky130_fd_pr__pfet_01v8 w=0.5 l=0.15
  xm15 N004 phi2 VCMFB 0 sky130_fd_pr__nfet_01v8 w=0.5 l=0.15
  xm16 VCMFB phi2b N004 VDD sky130_fd_pr__pfet_01v8 w=0.5 l=0.15
  C3 N002 N004 50f
  C4 vom VCMFB 10f
.ends Fig_26_50

.control
tran 1p 100n

let power = v(VDD) * abs(i(VDD))
let avg_power = mean(power)
print avg_power

meas tran vout_max MAX v(voutm)
meas tran vout_min MIN v(voutm)
let vout_swing = vout_max - vout_min
print vout_swing

meas tran rise_time TRIG v(voutm) VAL='0.1*vout_max' RISE=1 TARG v(voutm) VAL='0.9*vout_max' RISE=1
meas tran fall_time TRIG v(voutm) VAL='0.9*vout_max' FALL=1 TARG v(voutm) VAL='0.1*vout_max' FALL=1
print rise_time fall_time

quit
.endc

.end
