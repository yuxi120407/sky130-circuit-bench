* Testcase 001011 — Full Analysis (sky130 tt corner)
* SKY130 model header — replaces the ideal level-1 .model cards
* Ships with the demo; the paths point at the local sky130 PDK checkout.
* NOTE: libs.tech/ngspice/all.spice sets ".option scale=1.0u", so every
* instance L/W below is written in microns WITHOUT a "u" suffix.
.param mc_mm_switch=0
.param mc_pr_switch=0
.include /home/idies/workspace/Temporary/xyu1/scratch/skywater-pdk-libs-sky130_fd_pr/models/corners/tt.spice
.include /home/idies/workspace/Temporary/xyu1/scratch/skywater-pdk-libs-sky130_fd_pr/models/r+c/res_typical__cap_typical.spice
.include /home/idies/workspace/Temporary/xyu1/scratch/skywater-pdk-libs-sky130_fd_pr/models/r+c/res_typical__cap_typical__lin.spice
.include /home/idies/workspace/Temporary/xyu1/scratch/skywater-pdk-libs-sky130_fd_pr/models/corners/tt/specialized_cells.spice
.model DIDEAL D   is=1e-14 n=1
.options reltol=1e-3 itl1=500 itl2=100

* Sources
VVDD VDD 0 1.8
VLABEL_NET_0 LABEL_NET_0 0 DC 0.9 AC 0.5
VLABEL_NET_1 LABEL_NET_1 0 0.9
VLABEL_NET_3 LABEL_NET_3 0 0.9

* Circuit
XMCS N1 LABEL_NET_0 VDD GND sky130_fd_pr__nfet_01v8 l=0.5 w=5
XM2 VDD VDD VDD GND sky130_fd_pr__nfet_01v8 l=0.5 w=5
XM3 VDD VDD VDD VDD sky130_fd_pr__pfet_01v8 l=0.5 w=5
XMSA DUMP VDD VDD GND sky130_fd_pr__nfet_01v8 l=0.5 w=5
XMCAS VDD LABEL_NET_1 N1 GND sky130_fd_pr__nfet_01v8 l=0.5 w=5
XM6 VDD VDD VDD GND sky130_fd_pr__nfet_01v8 l=0.5 w=5
XM7 VDD VDD VDD VDD sky130_fd_pr__pfet_01v8 l=0.5 w=5
XM8 VDD VDD VDD VDD sky130_fd_pr__pfet_01v8 l=0.5 w=5
XMSB VDD VDD VDD GND sky130_fd_pr__nfet_01v8 l=0.5 w=5
XM10 VDD VDD VDD VDD sky130_fd_pr__pfet_01v8 l=0.5 w=5
XM11 LABEL_NET_3 VDD VDD GND sky130_fd_pr__nfet_01v8 l=0.5 w=5
XM12 VDD VDD VDD VDD sky130_fd_pr__pfet_01v8 l=0.5 w=5
XM13 LABEL_NET_3 VDD VDD GND sky130_fd_pr__nfet_01v8 l=0.5 w=5
RL1 VDD VDD 10k
RL2 VDD DUMP 10k
XM14 VDD VDD VDD GND sky130_fd_pr__nfet_01v8 l=0.5 w=5
XM15 CLOCK CLOCK VDD VDD sky130_fd_pr__pfet_01v8 l=0.5 w=5
XM16 VDD VDD VDD VDD sky130_fd_pr__pfet_01v8 l=0.5 w=5

.control
set filetype=ascii

op
let power_dc = abs(i(VVDD)) * 1.8
print power_dc

ac dec 100 1 10g
let vout_mag = vm(N1)
let gain_db = db(vout_mag)
let dc_gain_db = gain_db[0]
print dc_gain_db

if dc_gain_db > 0
    meas ac ugbw WHEN gain_db=0 CROSS=1
    print ugbw
end

quit
.endc

.end
