* Testcase 000282 — Full Analysis (sky130 tt corner)
* SKY130 model header — replaces the ideal level-1 .model cards
* Ships with the demo; the paths point at the local sky130 PDK checkout.
* NOTE: libs.tech/ngspice/all.spice sets ".option scale=1.0u", so every
* instance L/W below is written in microns WITHOUT a "u" suffix.
.param mc_mm_switch=0
.param mc_pr_switch=0
.include /home/idies/workspace/Temporary/xyu1/scratch/skywater-pdk-libs-sky130_fd_pr/models/corners/tt.spice
.include /home/idies/workspace/Temporary/xyu1/scratch/skywater-pdk-libs-sky130_fd_pr/models/r+c/res_typical__cap_typical.spice
.include /home/idies/workspace/Temporary/xyu1/scratch/skywater-pdk-libs-sky130_fd_pr/models/r+c/res_typical__cap_typical__lin.spice
.include /home/idies/workspace/Temporary/xyu1/scratch/skywater-pdk-libs-sky130_fd_pr/models/corners/tt/specialized_cells.spice
.model DIDEAL D   is=1e-14 n=1
.options reltol=1e-3 itl1=500 itl2=100

* Sources
VVDD VDD 0 1.8
VLABEL_NET_0 LABEL_NET_0 0 DC 0.9 AC 0.5
VLABEL_NET_1 LABEL_NET_1 0 DC 0.9 AC -0.5
VLABEL_NET_2 LABEL_NET_2 0 0.9
VLABEL_NET_3 LABEL_NET_3 0 0.9

* Circuit
I1 VDD N0 1u
XM1 N6 N1 GND GND sky130_fd_pr__nfet_01v8 l=0.5 w=5
XM2 N9 N3 GND GND sky130_fd_pr__nfet_01v8 l=0.5 w=5
I2 VDD N11 1u
XM3 N2 LABEL_NET_0 N9 GND sky130_fd_pr__nfet_01v8 l=0.5 w=5
R1 N8 GND 10k
XM4 N2 LABEL_NET_1 N6 GND sky130_fd_pr__nfet_01v8 l=0.5 w=5
XM5 N0 N0 N8 GND sky130_fd_pr__nfet_01v8 l=0.5 w=5
XM6 N2 N2 VDD VDD sky130_fd_pr__pfet_01v8 l=0.5 w=5
XM7 N2 LABEL_NET_2 N11 VDD sky130_fd_pr__pfet_01v8 l=0.5 w=5
XM8 N3 N7 N4 GND sky130_fd_pr__nfet_01v8 l=0.5 w=5
XM9 N2 N10 N6 GND sky130_fd_pr__nfet_01v8 l=0.5 w=5
XM10 N2 N2 VDD VDD sky130_fd_pr__pfet_01v8 l=0.5 w=5
XM11 N2 N10 N9 GND sky130_fd_pr__nfet_01v8 l=0.5 w=5
XM12 N1 N7 N5 GND sky130_fd_pr__nfet_01v8 l=0.5 w=5
XM13 N2 LABEL_NET_3 N11 VDD sky130_fd_pr__pfet_01v8 l=0.5 w=5
L1 VDD N3 10n
L2 N5 GND 10n
L3 N4 GND 10n
L4 VDD N1 10n

.control
set filetype=ascii

op
let vdd_current = abs(i(VVDD))
let power_dc = vdd_current * 1.8
print power_dc

ac dec 100 1k 100g
let vout_mag = vm(N8)
let gain_db = db(vout_mag)

meas ac max_gain_db MAX gain_db
meas ac bw_3db WHEN gain_db='max_gain_db-3' CROSS=1

print max_gain_db bw_3db

quit
.endc

.end
