* Testcase 000887 — Full Analysis (sky130 tt corner)
* SKY130 model header — replaces the ideal level-1 .model cards
* Ships with the demo; the paths point at the local sky130 PDK checkout.
* NOTE: libs.tech/ngspice/all.spice sets ".option scale=1.0u", so every
* instance L/W below is written in microns WITHOUT a "u" suffix.
.param mc_mm_switch=0
.param mc_pr_switch=0
.include /home/idies/workspace/Temporary/xyu1/scratch/skywater-pdk-libs-sky130_fd_pr/models/corners/tt.spice
.include /home/idies/workspace/Temporary/xyu1/scratch/skywater-pdk-libs-sky130_fd_pr/models/r+c/res_typical__cap_typical.spice
.include /home/idies/workspace/Temporary/xyu1/scratch/skywater-pdk-libs-sky130_fd_pr/models/r+c/res_typical__cap_typical__lin.spice
.include /home/idies/workspace/Temporary/xyu1/scratch/skywater-pdk-libs-sky130_fd_pr/models/corners/tt/specialized_cells.spice
.model DIDEAL D   is=1e-14 n=1
.options reltol=1e-3 itl1=500 itl2=100

* Sources

* Circuit
XQ1 N6 N3 N4 0 sky130_fd_pr__npn_05v5_W1p00L1p00
I1 N6 GND 1u
R1 N0 N8 10k
R2 N4 GND 10k
XQ2 N11 N3 N11 0 sky130_fd_pr__npn_05v5_W1p00L1p00
R3 N11 GND 10k
I2 N1 N2 1u
XQ3 N1 N2 N3 0 sky130_fd_pr__npn_05v5_W1p00L1p00
D1 N10 N8 DIDEAL
XQ4 N7 N0 GND 0 sky130_fd_pr__npn_05v5_W1p00L1p00
XQ5 N2 N3 N5 0 sky130_fd_pr__npn_05v5_W1p00L1p00
R4 N5 GND 10k
XQ6 N0 N0 GND 0 sky130_fd_pr__npn_05v5_W1p00L1p00
D2 N6 N9 DIDEAL
D3 N9 N10 DIDEAL

.control
set filetype=ascii

op
let power_dc = 0
print power_dc
let dc_voltage = v(N0)
print dc_voltage

quit
.endc

.end
