* Testcase 000855 — Full Analysis (sky130 tt corner)
* SKY130 model header — replaces the ideal level-1 .model cards
* Ships with the demo; the paths point at the local sky130 PDK checkout.
* NOTE: libs.tech/ngspice/all.spice sets ".option scale=1.0u", so every
* instance L/W below is written in microns WITHOUT a "u" suffix.
.param mc_mm_switch=0
.param mc_pr_switch=0
.include /home/idies/workspace/Temporary/xyu1/scratch/skywater-pdk-libs-sky130_fd_pr/models/corners/tt.spice
.include /home/idies/workspace/Temporary/xyu1/scratch/skywater-pdk-libs-sky130_fd_pr/models/r+c/res_typical__cap_typical.spice
.include /home/idies/workspace/Temporary/xyu1/scratch/skywater-pdk-libs-sky130_fd_pr/models/r+c/res_typical__cap_typical__lin.spice
.include /home/idies/workspace/Temporary/xyu1/scratch/skywater-pdk-libs-sky130_fd_pr/models/corners/tt/specialized_cells.spice
.model DIDEAL D   is=1e-14 n=1
.options reltol=1e-3 itl1=500 itl2=100

* Sources
VVDD VDD 0 1.8
VVSS VSS 0 0
VVBP1 VBP1 0 0.9900000000000001
VVBN2 VBN2 0 0.54
VVCM VCM 0 0.9

* Circuit
XM7A TO_CMFB_MINUS VOUT_MINUS N3 VSS sky130_fd_pr__nfet_01v8 l=0.5 w=5
XM7B TO_CMFB_PLUS VOUT_MINUS N3 VSS sky130_fd_pr__nfet_01v8 l=0.5 w=5
XM7C TO_CMFB_MINUS VOUT_PLUS N1 VSS sky130_fd_pr__nfet_01v8 l=0.5 w=5
XM7D TO_CMFB_PLUS VOUT_PLUS N1 VSS sky130_fd_pr__nfet_01v8 l=0.5 w=5
XM8_L TO_CMFB_MINUS VBP1 VDD VDD sky130_fd_pr__pfet_01v8 l=0.5 w=5
XM8_R TO_CMFB_PLUS VBP1 VDD VDD sky130_fd_pr__pfet_01v8 l=0.5 w=5
XM9_L N3 VBN2 VSS VSS sky130_fd_pr__nfet_01v8 l=0.5 w=5
XM9_R N1 VBN2 VSS VSS sky130_fd_pr__nfet_01v8 l=0.5 w=5
R_L N3 VCM 10k
R_R N1 VCM 10k

.control
set filetype=ascii

op
let vdd_current = abs(i(VVDD))
let power_dc = vdd_current * 1.8
print power_dc

print all

quit
.endc

.end
