* Testcase 000578 — Full Analysis (sky130 tt corner)
* SKY130 model header — replaces the ideal level-1 .model cards
* Ships with the demo; the paths point at the local sky130 PDK checkout.
* NOTE: libs.tech/ngspice/all.spice sets ".option scale=1.0u", so every
* instance L/W below is written in microns WITHOUT a "u" suffix.
.param mc_mm_switch=0
.param mc_pr_switch=0
.include /home/idies/workspace/Temporary/xyu1/scratch/skywater-pdk-libs-sky130_fd_pr/models/corners/tt.spice
.include /home/idies/workspace/Temporary/xyu1/scratch/skywater-pdk-libs-sky130_fd_pr/models/r+c/res_typical__cap_typical.spice
.include /home/idies/workspace/Temporary/xyu1/scratch/skywater-pdk-libs-sky130_fd_pr/models/r+c/res_typical__cap_typical__lin.spice
.include /home/idies/workspace/Temporary/xyu1/scratch/skywater-pdk-libs-sky130_fd_pr/models/corners/tt/specialized_cells.spice
.model DIDEAL D   is=1e-14 n=1
.options reltol=1e-3 itl1=500 itl2=100

* Sources
VVDD VDD 0 1.8

* Circuit
XM8 VDD N4 P3 GND sky130_fd_pr__nfet_01v8 l=0.5 w=5
R1 N0 VDD 10k
R2 N3 VDD 10k
R3 P4 GND 10k
R4 N2 VDD 10k
XM3 N4 P3_BAR N1 GND sky130_fd_pr__nfet_01v8 l=0.5 w=5
R5 P3 GND 10k
XM1 N0 P1_BAR N1 GND sky130_fd_pr__nfet_01v8 l=0.5 w=5
R6 P1 GND 10k
R7 N4 VDD 10k
XM7 VDD N3 P4 GND sky130_fd_pr__nfet_01v8 l=0.5 w=5
XM4 N3 P4_BAR N1 GND sky130_fd_pr__nfet_01v8 l=0.5 w=5
R8 P2 GND 10k
XM10 VDD N0 P1 GND sky130_fd_pr__nfet_01v8 l=0.5 w=5
XM6 N11 BIAS GND GND sky130_fd_pr__nfet_01v8 l=0.5 w=5
XM2 N2 P2_BAR N1 GND sky130_fd_pr__nfet_01v8 l=0.5 w=5
XM5 N1 BIAS N11 GND sky130_fd_pr__nfet_01v8 l=0.5 w=5
XM9 VDD N2 P2 GND sky130_fd_pr__nfet_01v8 l=0.5 w=5

.control
set filetype=ascii

op
let vdd_current = abs(i(VVDD))
let power_dc = vdd_current * 1.8
let vout_dc = v(P4)
print power_dc vout_dc

quit
.endc

.end
