* Testcase 000198 — Full Analysis (sky130 tt corner)
* SKY130 model header — replaces the ideal level-1 .model cards
* Ships with the demo; the paths point at the local sky130 PDK checkout.
* NOTE: libs.tech/ngspice/all.spice sets ".option scale=1.0u", so every
* instance L/W below is written in microns WITHOUT a "u" suffix.
.param mc_mm_switch=0
.param mc_pr_switch=0
.include /home/idies/workspace/Temporary/xyu1/scratch/skywater-pdk-libs-sky130_fd_pr/models/corners/tt.spice
.include /home/idies/workspace/Temporary/xyu1/scratch/skywater-pdk-libs-sky130_fd_pr/models/r+c/res_typical__cap_typical.spice
.include /home/idies/workspace/Temporary/xyu1/scratch/skywater-pdk-libs-sky130_fd_pr/models/r+c/res_typical__cap_typical__lin.spice
.include /home/idies/workspace/Temporary/xyu1/scratch/skywater-pdk-libs-sky130_fd_pr/models/corners/tt/specialized_cells.spice
.model DIDEAL D   is=1e-14 n=1
.options reltol=1e-3 itl1=500 itl2=100

* Sources
VVDD VDD 0 1.8
VVSS VSS 0 DC 0 AC 0.5

* Circuit
R1 SUBSTRATE N6 0.75
R2 N2 SUBSTRATE 0.21
R3 SUBSTRATE VSS 0.12
R4 SUBSTRATE N7 0.57
C1 VDDE VSS 145p
C2 VSS VSSE 218p
C3 VSSE N7 52p
C4 VDD N6 19p
C5 VDD VSS 77p
C6 VDDE N2 53p
C7 VDDE VSSE 42p
C8 VDD VSSE 30p
C9 VDD VDDE 33p

.control
set filetype=ascii

ac dec 100 1 100g

let vmag = vm(VSSE)
let vdb = db(vmag)

meas ac gain_1khz_db FIND vdb AT=1e3
meas ac gain_1mhz_db FIND vdb AT=1e6
meas ac gain_1ghz_db FIND vdb AT=1e9
meas ac max_gain_db MAX vdb
meas ac bw_3db_hz WHEN vdb='max_gain_db-3' CROSS=1

print gain_1khz_db gain_1mhz_db gain_1ghz_db max_gain_db bw_3db_hz

quit
.endc

.end
