* Testcase 000494 — Full Analysis (sky130 tt corner)
* SKY130 model header — replaces the ideal level-1 .model cards
* Ships with the demo; the paths point at the local sky130 PDK checkout.
* NOTE: libs.tech/ngspice/all.spice sets ".option scale=1.0u", so every
* instance L/W below is written in microns WITHOUT a "u" suffix.
.param mc_mm_switch=0
.param mc_pr_switch=0
.include /home/idies/workspace/Temporary/xyu1/scratch/skywater-pdk-libs-sky130_fd_pr/models/corners/tt.spice
.include /home/idies/workspace/Temporary/xyu1/scratch/skywater-pdk-libs-sky130_fd_pr/models/r+c/res_typical__cap_typical.spice
.include /home/idies/workspace/Temporary/xyu1/scratch/skywater-pdk-libs-sky130_fd_pr/models/r+c/res_typical__cap_typical__lin.spice
.include /home/idies/workspace/Temporary/xyu1/scratch/skywater-pdk-libs-sky130_fd_pr/models/corners/tt/specialized_cells.spice
.model DIDEAL D   is=1e-14 n=1
.options reltol=1e-3 itl1=500 itl2=100

* Sources
VVIN VIN 0 DC 0.9 AC 1 SIN(0.9 0.1 1MEG 0 0)

* Circuit
I1 p15V N1 1u
D3 N1 N2 DIDEAL
D4 N2 N3 DIDEAL
XQ6 n15V VIN N3 sky130_fd_pr__pnp_05v5_W3p40L3p40
XQ3 p15V VIN N4 0 sky130_fd_pr__npn_05v5_W1p00L1p00
D1 N4 N5 DIDEAL
D2 N5 N6 DIDEAL
I2 N6 n15V 1u
XQ1 p15V N1 N7 0 sky130_fd_pr__npn_05v5_W1p00L1p00
XQ2 N7 N3 VOUT 0 sky130_fd_pr__npn_05v5_W1p00L1p00
XQ5 N8 N4 VOUT sky130_fd_pr__pnp_05v5_W3p40L3p40
XQ4 n15V N6 N8 sky130_fd_pr__pnp_05v5_W3p40L3p40
D5 N7 p5V DIDEAL
D6 n5V N8 DIDEAL

.control
set filetype=ascii

op
let vdd_current = abs(i(VVDD))
let power_dc = vdd_current * 1.8
print power_dc

ac dec 100 1 10g
let vout_mag = vm(VOUT)
let gain_db = db(vout_mag)
let dc_gain_db = gain_db[0]
print dc_gain_db

if dc_gain_db > 0
    meas ac ugbw WHEN gain_db=0 CROSS=1
end

quit
.endc

.end
