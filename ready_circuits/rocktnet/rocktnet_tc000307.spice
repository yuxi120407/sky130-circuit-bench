* Testcase 000307 — Full Analysis (sky130 tt corner)
* SKY130 model header — replaces the ideal level-1 .model cards
* Ships with the demo; the paths point at the local sky130 PDK checkout.
* NOTE: libs.tech/ngspice/all.spice sets ".option scale=1.0u", so every
* instance L/W below is written in microns WITHOUT a "u" suffix.
.param mc_mm_switch=0
.param mc_pr_switch=0
.include /home/idies/workspace/Temporary/xyu1/scratch/skywater-pdk-libs-sky130_fd_pr/models/corners/tt.spice
.include /home/idies/workspace/Temporary/xyu1/scratch/skywater-pdk-libs-sky130_fd_pr/models/r+c/res_typical__cap_typical.spice
.include /home/idies/workspace/Temporary/xyu1/scratch/skywater-pdk-libs-sky130_fd_pr/models/r+c/res_typical__cap_typical__lin.spice
.include /home/idies/workspace/Temporary/xyu1/scratch/skywater-pdk-libs-sky130_fd_pr/models/corners/tt/specialized_cells.spice
.model DIDEAL D   is=1e-14 n=1
.options reltol=1e-3 itl1=500 itl2=100

* Sources
VVDD VDD 0 1.8
VVSS VSS 0 DC 0 AC 0.5
VVCTRL VCTRL 0 0.9

* Circuit
XM1 N5 VCTRL VSS VSS sky130_fd_pr__nfet_01v8 l=0.5 w=5
XM2 N1 N3 N4 VSS sky130_fd_pr__nfet_01v8 l=0.5 w=5
XM3 N1 N1 N0 VDD sky130_fd_pr__pfet_01v8 l=0.5 w=5
XM4 IOUT N1 N6 VDD sky130_fd_pr__pfet_01v8 l=0.5 w=5
XM5 N3 N3 VSS VSS sky130_fd_pr__nfet_01v8 l=0.5 w=5
XM6 N0 N0 VDD VDD sky130_fd_pr__pfet_01v8 l=0.5 w=5
R1 N4 N5 10k
XM7 N6 N0 VDD VDD sky130_fd_pr__pfet_01v8 l=0.5 w=5
XM8 N3 N1 N9 VDD sky130_fd_pr__pfet_01v8 l=0.5 w=5
XM9 N9 N0 VDD VDD sky130_fd_pr__pfet_01v8 l=0.5 w=5

.control
set filetype=ascii

op
let power_dc = abs(i(VVDD)) * 1.8
print power_dc

ac dec 100 1 10g
let vout_mag = vm(N5)
let gain_db = db(vout_mag)
let dc_gain_db = gain_db[0]
print dc_gain_db

if dc_gain_db > 0
    meas ac ugbw WHEN gain_db=0 CROSS=1
    print ugbw
end

quit
.endc

.end
