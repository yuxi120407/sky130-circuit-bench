* Testcase 000292 — Full Analysis (sky130 tt corner)
* SKY130 model header — replaces the ideal level-1 .model cards
* Ships with the demo; the paths point at the local sky130 PDK checkout.
* NOTE: libs.tech/ngspice/all.spice sets ".option scale=1.0u", so every
* instance L/W below is written in microns WITHOUT a "u" suffix.
.param mc_mm_switch=0
.param mc_pr_switch=0
.include /home/idies/workspace/Temporary/xyu1/scratch/skywater-pdk-libs-sky130_fd_pr/models/corners/tt.spice
.include /home/idies/workspace/Temporary/xyu1/scratch/skywater-pdk-libs-sky130_fd_pr/models/r+c/res_typical__cap_typical.spice
.include /home/idies/workspace/Temporary/xyu1/scratch/skywater-pdk-libs-sky130_fd_pr/models/r+c/res_typical__cap_typical__lin.spice
.include /home/idies/workspace/Temporary/xyu1/scratch/skywater-pdk-libs-sky130_fd_pr/models/corners/tt/specialized_cells.spice
.model DIDEAL D   is=1e-14 n=1
.options reltol=1e-3 itl1=500 itl2=100

* Sources
VVDD VDD 0 1.8
VVINp VINp 0 DC 0.9 AC 1 SIN(0.9 0.1 1MEG 0 0)
VVINn VINn 0 DC 0.9 AC 1 SIN(0.9 0.1 1MEG 0 0)

* Circuit
R1 VDD VOUT1 10k
R2 VDD VOUT2 10k
XM1 N_M1D VINp GND GND sky130_fd_pr__nfet_01v8 l=0.5 w=5
XM2 N_M2D VINn GND GND sky130_fd_pr__nfet_01v8 l=0.5 w=5
XM3 VOUT1 VLOp N_M1D GND sky130_fd_pr__nfet_01v8 l=0.5 w=5
XM4 VOUT2 VLOn N_M1D GND sky130_fd_pr__nfet_01v8 l=0.5 w=5
XM5 VOUT1 VLOn N_M2D GND sky130_fd_pr__nfet_01v8 l=0.5 w=5
XM6 VOUT2 VLOp N_M2D GND sky130_fd_pr__nfet_01v8 l=0.5 w=5
XM1A N_M1AD VINp GND GND sky130_fd_pr__nfet_01v8 l=0.5 w=5
XM2A N_M2AD VINn GND GND sky130_fd_pr__nfet_01v8 l=0.5 w=5
XM3A N_GC1 VLOn N_M1AD GND sky130_fd_pr__nfet_01v8 l=0.5 w=5
XM4A N_GC2 VLOp N_M1AD GND sky130_fd_pr__nfet_01v8 l=0.5 w=5
XM5A N_GC1 VLOp N_M2AD GND sky130_fd_pr__nfet_01v8 l=0.5 w=5
XM6A N_GC2 VLOn N_M2AD GND sky130_fd_pr__nfet_01v8 l=0.5 w=5
XM7 VOUT1 VGp N_GC1 GND sky130_fd_pr__nfet_01v8 l=0.5 w=5
XM8 VOUT2 VGn N_GC1 GND sky130_fd_pr__nfet_01v8 l=0.5 w=5
XM9 VOUT1 VGp N_GC2 GND sky130_fd_pr__nfet_01v8 l=0.5 w=5
XM10 VOUT2 VGn N_GC2 GND sky130_fd_pr__nfet_01v8 l=0.5 w=5

.control
set filetype=ascii

op
let vdd_current = abs(i(VVDD))
let power_dc = vdd_current * 1.8
print power_dc

print all

quit
.endc

.end
