* Testcase 000179 — Full Analysis (sky130 tt corner)
* SKY130 model header — replaces the ideal level-1 .model cards
* Ships with the demo; the paths point at the local sky130 PDK checkout.
* NOTE: libs.tech/ngspice/all.spice sets ".option scale=1.0u", so every
* instance L/W below is written in microns WITHOUT a "u" suffix.
.param mc_mm_switch=0
.param mc_pr_switch=0
.include /home/idies/workspace/Temporary/xyu1/scratch/skywater-pdk-libs-sky130_fd_pr/models/corners/tt.spice
.include /home/idies/workspace/Temporary/xyu1/scratch/skywater-pdk-libs-sky130_fd_pr/models/r+c/res_typical__cap_typical.spice
.include /home/idies/workspace/Temporary/xyu1/scratch/skywater-pdk-libs-sky130_fd_pr/models/r+c/res_typical__cap_typical__lin.spice
.include /home/idies/workspace/Temporary/xyu1/scratch/skywater-pdk-libs-sky130_fd_pr/models/corners/tt/specialized_cells.spice
.model DIDEAL D   is=1e-14 n=1
.options reltol=1e-3 itl1=500 itl2=100

* Sources
VLABEL_NET_0 LABEL_NET_0 0 0.9
VLABEL_NET_3 LABEL_NET_3 0 0.9

* Circuit
XM1 N1 N14 GND GND sky130_fd_pr__nfet_01v8 l=0.5 w=5
XQ1 N18 BB_I_P LABEL_NET_0 0 sky130_fd_pr__npn_05v5_W1p00L1p00
XQ2 N10 LO_I_P N17 0 sky130_fd_pr__npn_05v5_W1p00L1p00
XQ3 N5 LO_I_N 3V 0 sky130_fd_pr__npn_05v5_W1p00L1p00
XQ4 N18 BB_I_N LABEL_NET_3 0 sky130_fd_pr__npn_05v5_W1p00L1p00
XM2 N16 N0 GND GND sky130_fd_pr__nfet_01v8 l=0.5 w=5
XM3 N3 N14 GND GND sky130_fd_pr__nfet_01v8 l=0.5 w=5
XQ5 N18 3V N5 0 sky130_fd_pr__npn_05v5_W1p00L1p00
XM4 N8 N0 GND GND sky130_fd_pr__nfet_01v8 l=0.5 w=5
XQ6 OP_Q_MIXER N18 N18 0 sky130_fd_pr__npn_05v5_W1p00L1p00
XQ7 3V N3 N11 0 sky130_fd_pr__npn_05v5_W1p00L1p00
XQ8 LO_I_N 3V N10 0 sky130_fd_pr__npn_05v5_W1p00L1p00
XQ9 3V N12 N1 0 sky130_fd_pr__npn_05v5_W1p00L1p00
XM5 N12 N0 N3 GND sky130_fd_pr__nfet_01v8 l=0.5 w=5
XM6 N11 N14 N1 GND sky130_fd_pr__nfet_01v8 l=0.5 w=5
XQ10 OP_Q_MIXER N18 N18 0 sky130_fd_pr__npn_05v5_W1p00L1p00
XQ11 OP_Q_MIXER LO_I_N N18 0 sky130_fd_pr__npn_05v5_W1p00L1p00
XQ12 3V OP_Q_MIXER N3 0 sky130_fd_pr__npn_05v5_W1p00L1p00
R1 3V LO_I_N 10k
XQ13 OP_Q_MIXER LO_I_N N18 0 sky130_fd_pr__npn_05v5_W1p00L1p00
R2 3V 3V 10k
R3 OP_Q_MIXER 3V 10k
XQ14 3V OP_Q_MIXER N12 0 sky130_fd_pr__npn_05v5_W1p00L1p00
R4 OP_Q_MIXER 3V 10k
R5 N16 LABEL_NET_3 10k
R6 N16 LABEL_NET_0 10k
R7 N8 N17 10k
R8 N1 V_OUT 10k
R9 V_OUT N11 10k
R10 N8 3V 10k

.control
set filetype=ascii

op
let power_dc = abs(i(VLABEL_NET_0)) * 1.8
print power_dc
let dc_voltage = v(3V)
print dc_voltage

quit
.endc

.end
