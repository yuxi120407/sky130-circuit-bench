* Testcase 000481 — Full Analysis (sky130 tt corner)
* SKY130 model header — replaces the ideal level-1 .model cards
* Ships with the demo; the paths point at the local sky130 PDK checkout.
* NOTE: libs.tech/ngspice/all.spice sets ".option scale=1.0u", so every
* instance L/W below is written in microns WITHOUT a "u" suffix.
.param mc_mm_switch=0
.param mc_pr_switch=0
.include /home/idies/workspace/Temporary/xyu1/scratch/skywater-pdk-libs-sky130_fd_pr/models/corners/tt.spice
.include /home/idies/workspace/Temporary/xyu1/scratch/skywater-pdk-libs-sky130_fd_pr/models/r+c/res_typical__cap_typical.spice
.include /home/idies/workspace/Temporary/xyu1/scratch/skywater-pdk-libs-sky130_fd_pr/models/r+c/res_typical__cap_typical__lin.spice
.include /home/idies/workspace/Temporary/xyu1/scratch/skywater-pdk-libs-sky130_fd_pr/models/corners/tt/specialized_cells.spice
.model DIDEAL D   is=1e-14 n=1
.options reltol=1e-3 itl1=500 itl2=100

* Sources
VVDD VDD 0 1.8
VVIN_PLUS VIN_PLUS 0 DC 0.9 AC 1 SIN(0.9 0.1 1MEG 0 0)
VVIN_MINUS VIN_MINUS 0 DC 0.9 AC 1 SIN(0.9 0.1 1MEG 0 0)
VVCLK2 VCLK2 0 0.0
VVBIASN VBIASN 0 0.9900000000000001

* Circuit
XM1 VOUT_PLUS VOUT_MINUS VDD VDD sky130_fd_pr__pfet_01v8 l=0.5 w=5
I1 N0 GND 1u
XM2 VOUT_MINUS VOUT_PLUS VDD VDD sky130_fd_pr__pfet_01v8 l=0.5 w=5
XM3 VOUT_PLUS VIN_PLUS N0 GND sky130_fd_pr__nfet_01v8 l=0.5 w=5
XM4 VOUT_MINUS VIN_MINUS N0 GND sky130_fd_pr__nfet_01v8 l=0.5 w=5
XM5 VOUT_MINUS VCLK2 VOUT_PLUS VDD sky130_fd_pr__pfet_01v8 l=0.5 w=5
XM0 VOUT_MINUS VBIASN VOUT_PLUS VDD sky130_fd_pr__pfet_01v8 l=0.5 w=5

.control
set filetype=ascii

op
let vdd_current = abs(i(VVDD))
let power_dc = vdd_current * 1.8
print power_dc

print all

quit
.endc

.end
