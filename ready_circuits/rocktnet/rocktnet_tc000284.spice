* Testcase 000284 — Full Analysis (sky130 tt corner)
* SKY130 model header — replaces the ideal level-1 .model cards
* Ships with the demo; the paths point at the local sky130 PDK checkout.
* NOTE: libs.tech/ngspice/all.spice sets ".option scale=1.0u", so every
* instance L/W below is written in microns WITHOUT a "u" suffix.
.param mc_mm_switch=0
.param mc_pr_switch=0
.include /home/idies/workspace/Temporary/xyu1/scratch/skywater-pdk-libs-sky130_fd_pr/models/corners/tt.spice
.include /home/idies/workspace/Temporary/xyu1/scratch/skywater-pdk-libs-sky130_fd_pr/models/r+c/res_typical__cap_typical.spice
.include /home/idies/workspace/Temporary/xyu1/scratch/skywater-pdk-libs-sky130_fd_pr/models/r+c/res_typical__cap_typical__lin.spice
.include /home/idies/workspace/Temporary/xyu1/scratch/skywater-pdk-libs-sky130_fd_pr/models/corners/tt/specialized_cells.spice
.model DIDEAL D   is=1e-14 n=1
.options reltol=1e-3 itl1=500 itl2=100

* Sources
VINN INN 0 DC 0.9 AC 1 SIN(0.9 0.1 1MEG 0 0)
VIN IN 0 DC 0.9 AC 1 SIN(0.9 0.1 1MEG 0 0)

* Circuit
XQ1 N14 OUTN N1 0 sky130_fd_pr__npn_05v5_W1p00L1p00
XQ2 N8 N8 N5 0 sky130_fd_pr__npn_05v5_W1p00L1p00
R2 OUT_I_Q GND 10k
R1 N0 TUNE1 10k
R3 OUTN GND 10k
R4 N5 GND 10k
R5 N10 GND 10k
R6 OUT GND 10k
R7 N3 GND 10k
R8 N4 N15 10k
R9 OUTN_I_Q GND 10k
R10 N12 GND 10k
R11 N11 N15 10k
R12 VCC N8 10k
XQ3 N1 N8 N3 0 sky130_fd_pr__npn_05v5_W1p00L1p00
XQ4 N1 N0 N12 0 sky130_fd_pr__npn_05v5_W1p00L1p00
XQ5 N16 OUT N1 0 sky130_fd_pr__npn_05v5_W1p00L1p00
XQ6 N1 N0 N11 0 sky130_fd_pr__npn_05v5_W1p00L1p00
XQ7 N14 INN N1 0 sky130_fd_pr__npn_05v5_W1p00L1p00
XQ8 VCC OUT OUT_I_Q 0 sky130_fd_pr__npn_05v5_W1p00L1p00
XQ9 N1 N8 N4 0 sky130_fd_pr__npn_05v5_W1p00L1p00
XQ10 N0 N0 N10 0 sky130_fd_pr__npn_05v5_W1p00L1p00
XQ11 VCC OUTN OUTN_I_Q 0 sky130_fd_pr__npn_05v5_W1p00L1p00
XQ12 N16 IN N1 0 sky130_fd_pr__npn_05v5_W1p00L1p00
L1 VCC N14 10n
L2 VCC N16 10n
XQ13 VCC VCC VCC sky130_fd_pr__pnp_05v5_W3p40L3p40
XQ14 VCC N16 OUTN 0 sky130_fd_pr__npn_05v5_W1p00L1p00
XQ15 VCC N14 OUT 0 sky130_fd_pr__npn_05v5_W1p00L1p00

.control
set filetype=ascii

op
let vdd_current = abs(i(VVDD))
let power_dc = vdd_current * 1.8
print power_dc

ac dec 100 1k 100g
let vout_mag = vm(OUT)
let gain_db = db(vout_mag)

meas ac max_gain_db MAX gain_db
meas ac bw_3db WHEN gain_db='max_gain_db-3' CROSS=1

print max_gain_db bw_3db

quit
.endc

.end
