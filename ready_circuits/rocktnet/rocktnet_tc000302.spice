* Testcase 000302 — Full Analysis (sky130 tt corner)
* SKY130 model header — replaces the ideal level-1 .model cards
* Ships with the demo; the paths point at the local sky130 PDK checkout.
* NOTE: libs.tech/ngspice/all.spice sets ".option scale=1.0u", so every
* instance L/W below is written in microns WITHOUT a "u" suffix.
.param mc_mm_switch=0
.param mc_pr_switch=0
.include /home/idies/workspace/Temporary/xyu1/scratch/skywater-pdk-libs-sky130_fd_pr/models/corners/tt.spice
.include /home/idies/workspace/Temporary/xyu1/scratch/skywater-pdk-libs-sky130_fd_pr/models/r+c/res_typical__cap_typical.spice
.include /home/idies/workspace/Temporary/xyu1/scratch/skywater-pdk-libs-sky130_fd_pr/models/r+c/res_typical__cap_typical__lin.spice
.include /home/idies/workspace/Temporary/xyu1/scratch/skywater-pdk-libs-sky130_fd_pr/models/corners/tt/specialized_cells.spice
.model DIDEAL D   is=1e-14 n=1
.options reltol=1e-3 itl1=500 itl2=100

* Sources
VLABEL_NET_0 LABEL_NET_0 0 DC 0.9 AC 0.5

* Circuit
D1 N3 N0 DIDEAL
R1 N6 N12 10k
R2 N1 N4 10k
D2 N9 N13 DIDEAL
R3 N14 GND 10k
R4 N6 N8 10k
R5 N5 GND 10k
R6 N6 N7 10k
R7 N15 GND 10k
XQ1 N2 N2 N11 0 sky130_fd_pr__npn_05v5_W1p00L1p00
XQ2 N4 N2 N10 0 sky130_fd_pr__npn_05v5_W1p00L1p00
D3 N7 N9 DIDEAL
R8 N14 GND 10k
R9 N6 GND 10k
R10 N11 N13 10k
R11 N10 N13 10k
R12 N0 N15 10k
R13 N0 N13 10k
R14 N3 N4 10k
R15 N3 LABEL_NET_0 10k
R16 N1 N6 10k
R17 N2 GND 10k
C1 N5 GND 1p
XQ3 N5 N12 N6 0 sky130_fd_pr__npn_05v5_W1p00L1p00
XQ4 N14 N8 LABEL_NET_0 0 sky130_fd_pr__npn_05v5_W1p00L1p00
C2 N14 GND 1p
D4 N1 N0 DIDEAL
R18 N14 GND 10k

.control
set filetype=ascii

op
let vdd_current = abs(i(VVDD))
let power_dc = vdd_current * 1.8
print power_dc

ac dec 100 1 10g
let vout_mag = vm(N14)
let gain_db = db(vout_mag)
let dc_gain_db = gain_db[0]
print dc_gain_db

if dc_gain_db > 0
    meas ac ugbw WHEN gain_db=0 CROSS=1
end

quit
.endc

.end
