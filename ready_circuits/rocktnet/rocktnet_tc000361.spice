* Testcase 000361 — Full Analysis (sky130 tt corner)
* SKY130 model header — replaces the ideal level-1 .model cards
* Ships with the demo; the paths point at the local sky130 PDK checkout.
* NOTE: libs.tech/ngspice/all.spice sets ".option scale=1.0u", so every
* instance L/W below is written in microns WITHOUT a "u" suffix.
.param mc_mm_switch=0
.param mc_pr_switch=0
.include /home/idies/workspace/Temporary/xyu1/scratch/skywater-pdk-libs-sky130_fd_pr/models/corners/tt.spice
.include /home/idies/workspace/Temporary/xyu1/scratch/skywater-pdk-libs-sky130_fd_pr/models/r+c/res_typical__cap_typical.spice
.include /home/idies/workspace/Temporary/xyu1/scratch/skywater-pdk-libs-sky130_fd_pr/models/r+c/res_typical__cap_typical__lin.spice
.include /home/idies/workspace/Temporary/xyu1/scratch/skywater-pdk-libs-sky130_fd_pr/models/corners/tt/specialized_cells.spice
.model DIDEAL D   is=1e-14 n=1
.options reltol=1e-3 itl1=500 itl2=100

* Sources
VVDD VDD 0 1.8

* Circuit
I1 VDD N2 1u
XM10 N1 N2 GND GND sky130_fd_pr__nfet_01v8 l=0.5 w=5
XM8 VDD UPB N1 GND sky130_fd_pr__nfet_01v8 l=0.5 w=5
XM12 N2 N2 GND GND sky130_fd_pr__nfet_01v8 l=0.5 w=5
R N0 N3 10k
XM7 VCP N3 N4 VDD sky130_fd_pr__pfet_01v8 l=0.5 w=5
XM9 N3 UP N1 GND sky130_fd_pr__nfet_01v8 l=0.5 w=5
XM5 N0 N3 N5 VDD sky130_fd_pr__pfet_01v8 l=0.5 w=5
XM6 N4 N0 VDD VDD sky130_fd_pr__pfet_01v8 l=0.5 w=5
XM4 N5 N0 VDD VDD sky130_fd_pr__pfet_01v8 l=0.5 w=5

.control
set filetype=ascii

op
let vdd_current = abs(i(VVDD))
let power_dc = vdd_current * 1.8
print power_dc

print all

let vout_dc = v(N1)
print vout_dc
let vout_dc = v(N2)
print vout_dc
quit
.endc

.end
