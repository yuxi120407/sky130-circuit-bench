* Testcase 001189 — Full Analysis (sky130 tt corner)
* SKY130 model header — replaces the ideal level-1 .model cards
* Ships with the demo; the paths point at the local sky130 PDK checkout.
* NOTE: libs.tech/ngspice/all.spice sets ".option scale=1.0u", so every
* instance L/W below is written in microns WITHOUT a "u" suffix.
.param mc_mm_switch=0
.param mc_pr_switch=0
.include /home/idies/workspace/Temporary/xyu1/scratch/skywater-pdk-libs-sky130_fd_pr/models/corners/tt.spice
.include /home/idies/workspace/Temporary/xyu1/scratch/skywater-pdk-libs-sky130_fd_pr/models/r+c/res_typical__cap_typical.spice
.include /home/idies/workspace/Temporary/xyu1/scratch/skywater-pdk-libs-sky130_fd_pr/models/r+c/res_typical__cap_typical__lin.spice
.include /home/idies/workspace/Temporary/xyu1/scratch/skywater-pdk-libs-sky130_fd_pr/models/corners/tt/specialized_cells.spice
.model DIDEAL D   is=1e-14 n=1
.options reltol=1e-3 itl1=500 itl2=100

* Sources
VVDD VDD 0 1.8
VVB1 VB1 0 0.9900000000000001
VVINp VINp 0 DC 0.9 AC 1 SIN(0.9 0.1 1MEG 0 0)
VVINn VINn 0 DC 0.9 AC 1 SIN(0.9 0.1 1MEG 0 0)

* Circuit
XQ1 VOUTn VLOp N0 0 sky130_fd_pr__npn_05v5_W1p00L1p00
XQ2 VOUTn VLOn N3 0 sky130_fd_pr__npn_05v5_W1p00L1p00
XQ3 VOUTp VLOp N3 0 sky130_fd_pr__npn_05v5_W1p00L1p00
XQ4 VOUTp VLOn N0 0 sky130_fd_pr__npn_05v5_W1p00L1p00
XM3 VOUTn VB1 VDD VDD sky130_fd_pr__pfet_01v8 l=0.5 w=5
XM1 VOUTp VB1 VDD VDD sky130_fd_pr__pfet_01v8 l=0.5 w=5
XM2 N3 VINp GND GND sky130_fd_pr__nfet_01v8 l=0.5 w=5
XM4 N0 VINn GND GND sky130_fd_pr__nfet_01v8 l=0.5 w=5
R1 VOUTn VDD 10k
R2 VOUTp VDD 10k
C1 VOUTp VOUTn 1p
C2 VOUTp VDD 1p
C3 VOUTn VDD 1p

.control
set filetype=ascii

op
let vdd_current = abs(i(VVDD))
let power_dc = vdd_current * 1.8
print power_dc

print all

quit
.endc

.end
