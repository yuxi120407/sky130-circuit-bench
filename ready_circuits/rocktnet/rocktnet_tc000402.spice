* Testcase 000402 — Full Analysis (sky130 tt corner)
* SKY130 model header — replaces the ideal level-1 .model cards
* Ships with the demo; the paths point at the local sky130 PDK checkout.
* NOTE: libs.tech/ngspice/all.spice sets ".option scale=1.0u", so every
* instance L/W below is written in microns WITHOUT a "u" suffix.
.param mc_mm_switch=0
.param mc_pr_switch=0
.include /home/idies/workspace/Temporary/xyu1/scratch/skywater-pdk-libs-sky130_fd_pr/models/corners/tt.spice
.include /home/idies/workspace/Temporary/xyu1/scratch/skywater-pdk-libs-sky130_fd_pr/models/r+c/res_typical__cap_typical.spice
.include /home/idies/workspace/Temporary/xyu1/scratch/skywater-pdk-libs-sky130_fd_pr/models/r+c/res_typical__cap_typical__lin.spice
.include /home/idies/workspace/Temporary/xyu1/scratch/skywater-pdk-libs-sky130_fd_pr/models/corners/tt/specialized_cells.spice
.model DIDEAL D   is=1e-14 n=1
.options reltol=1e-3 itl1=500 itl2=100

* Sources
VVDD VDD 0 1.8

* Circuit
XM1 V2 V1 VS1 GND sky130_fd_pr__nfet_01v8 l=0.5 w=5
XM2 V1 V2 VS1 GND sky130_fd_pr__nfet_01v8 l=0.5 w=5
XM3 V4 V3 VS2 GND sky130_fd_pr__nfet_01v8 l=0.5 w=5
XM4 V3 V4 VS2 GND sky130_fd_pr__nfet_01v8 l=0.5 w=5
L1 VDD V4 10n
L2 VDD V2 10n
C1 VS2 GND 1p
C2 VS1 GND 1p
C3 VDD V3 1p
L3 VS1 VC 10n
C4 VDD V2 1p
C5 VDD V1 1p
C6 VDD V4 1p
L4 VDD V1 10n
L5 V3 V3 10n
L6 VS2 VC 10n
I1 VC GND 1u

.control
set filetype=ascii

op
let vdd_current = abs(i(VVDD))
let power_dc = vdd_current * 1.8
print power_dc

ac dec 100 1k 100g
let vout_mag = vm(VS2)
let gain_db = db(vout_mag)

meas ac max_gain_db MAX gain_db
meas ac bw_3db WHEN gain_db='max_gain_db-3' CROSS=1

print max_gain_db bw_3db

quit
.endc

.end
