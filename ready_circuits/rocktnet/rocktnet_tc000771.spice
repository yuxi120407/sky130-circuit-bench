* Testcase 000771 — Full Analysis (sky130 tt corner)
* SKY130 model header — replaces the ideal level-1 .model cards
* Ships with the demo; the paths point at the local sky130 PDK checkout.
* NOTE: libs.tech/ngspice/all.spice sets ".option scale=1.0u", so every
* instance L/W below is written in microns WITHOUT a "u" suffix.
.param mc_mm_switch=0
.param mc_pr_switch=0
.include /home/idies/workspace/Temporary/xyu1/scratch/skywater-pdk-libs-sky130_fd_pr/models/corners/tt.spice
.include /home/idies/workspace/Temporary/xyu1/scratch/skywater-pdk-libs-sky130_fd_pr/models/r+c/res_typical__cap_typical.spice
.include /home/idies/workspace/Temporary/xyu1/scratch/skywater-pdk-libs-sky130_fd_pr/models/r+c/res_typical__cap_typical__lin.spice
.include /home/idies/workspace/Temporary/xyu1/scratch/skywater-pdk-libs-sky130_fd_pr/models/corners/tt/specialized_cells.spice
.model DIDEAL D   is=1e-14 n=1
.options reltol=1e-3 itl1=500 itl2=100

* Sources
VVDD VDD 0 1.8
VLABEL_NET_0 LABEL_NET_0 0 0.9
VLABEL_NET_1 LABEL_NET_1 0 0.9
VLABEL_NET_2 LABEL_NET_2 0 0.9
VLABEL_NET_3 LABEL_NET_3 0 0.9
VLABEL_NET_4 LABEL_NET_4 0 0.9
VLABEL_NET_6 LABEL_NET_6 0 0.9
VLABEL_NET_7 LABEL_NET_7 0 0.9
VLABEL_NET_8 LABEL_NET_8 0 0.9
VLABEL_NET_9 LABEL_NET_9 0 0.9
VLABEL_NET_10 LABEL_NET_10 0 0.9
VLABEL_NET_11 LABEL_NET_11 0 0.9

* Circuit
XM1 N3 N3 LABEL_NET_0 VDD sky130_fd_pr__pfet_01v8 l=0.5 w=5
XM2 N1 N1 LABEL_NET_1 VDD sky130_fd_pr__pfet_01v8 l=0.5 w=5
XM3 N8 N8 GND GND sky130_fd_pr__nfet_01v8 l=0.5 w=5
XM4 N2 N2 LABEL_NET_2 VDD sky130_fd_pr__pfet_01v8 l=0.5 w=5
XM5 N9 N1 LABEL_NET_3 VDD sky130_fd_pr__pfet_01v8 l=0.5 w=5
XQ1 N1 LABEL_NET_4 N4 0 sky130_fd_pr__npn_05v5_W1p00L1p00
XM6 N9 N8 GND GND sky130_fd_pr__nfet_01v8 l=0.5 w=5
XM7 N8 N7 N2 VDD sky130_fd_pr__pfet_01v8 l=0.5 w=5
R1 N6 GND 10k
XM8 N7 N7 LABEL_NET_6 VDD sky130_fd_pr__pfet_01v8 l=0.5 w=5
R2 N5 GND 10k
XQ2 N4 LABEL_NET_7 N5 0 sky130_fd_pr__npn_05v5_W1p00L1p00
XQ3 N3 LABEL_NET_8 N4 0 sky130_fd_pr__npn_05v5_W1p00L1p00
XQ4 N7 LABEL_NET_9 N0 0 sky130_fd_pr__npn_05v5_W1p00L1p00
XQ5 N0 LABEL_NET_10 N6 0 sky130_fd_pr__npn_05v5_W1p00L1p00
XQ6 N2 LABEL_NET_11 N0 0 sky130_fd_pr__npn_05v5_W1p00L1p00

.control
set filetype=ascii

op
let vdd_current = abs(i(VVDD))
let power_dc = vdd_current * 1.8
let vout_dc = v(N6)
print power_dc vout_dc

quit
.endc

.end
