* Testcase 000717 — Full Analysis (sky130 tt corner)
* SKY130 model header — replaces the ideal level-1 .model cards
* Ships with the demo; the paths point at the local sky130 PDK checkout.
* NOTE: libs.tech/ngspice/all.spice sets ".option scale=1.0u", so every
* instance L/W below is written in microns WITHOUT a "u" suffix.
.param mc_mm_switch=0
.param mc_pr_switch=0
.include /home/idies/workspace/Temporary/xyu1/scratch/skywater-pdk-libs-sky130_fd_pr/models/corners/tt.spice
.include /home/idies/workspace/Temporary/xyu1/scratch/skywater-pdk-libs-sky130_fd_pr/models/r+c/res_typical__cap_typical.spice
.include /home/idies/workspace/Temporary/xyu1/scratch/skywater-pdk-libs-sky130_fd_pr/models/r+c/res_typical__cap_typical__lin.spice
.include /home/idies/workspace/Temporary/xyu1/scratch/skywater-pdk-libs-sky130_fd_pr/models/corners/tt/specialized_cells.spice
.model DIDEAL D   is=1e-14 n=1
.options reltol=1e-3 itl1=500 itl2=100

* Sources
VLABEL_NET_0 LABEL_NET_0 0 DC 0.9 AC 0.5
VLABEL_NET_1 LABEL_NET_1 0 DC 0.9 AC -0.5
VLABEL_NET_2 LABEL_NET_2 0 0.9
VLABEL_NET_3 LABEL_NET_3 0 0.9
VLABEL_NET_4 LABEL_NET_4 0 0.9
VLABEL_NET_5 LABEL_NET_5 0 0.9
VLABEL_NET_6 LABEL_NET_6 0 0.9
VLABEL_NET_7 LABEL_NET_7 0 0.9
VLABEL_NET_8 LABEL_NET_8 0 0.9
VLABEL_NET_9 LABEL_NET_9 0 0.9

* Circuit
R1 N3 LABEL_NET_0 10k
R2 N2 LABEL_NET_1 10k
XQ1 N5 N2 N12 0 sky130_fd_pr__npn_05v5_W1p00L1p00
R3 N3 LABEL_NET_2 10k
R4 N1 N7 10k
XQ2 N2 N2 N1 0 sky130_fd_pr__npn_05v5_W1p00L1p00
R5 N0 LABEL_NET_3 10k
XQ3 N1 LABEL_NET_4 N1 0 sky130_fd_pr__npn_05v5_W1p00L1p00
C1 N8 N9 1p
C2 N0 LABEL_NET_5 1p
R6 N6 LABEL_NET_6 10k
C3 N3 LABEL_NET_7 1p
C4 N10 N2 1p
XQ4 N12 N9 N6 0 sky130_fd_pr__npn_05v5_W1p00L1p00
C5 N2 N12 1p
C6 N1 LABEL_NET_8 1p
R7 N5 N10 10k
L1 N8 N11 10n
R8 N0 N8 10k
XQ5 N11 N3 N13 sky130_fd_pr__pnp_05v5_W3p40L3p40
R9 N4 LABEL_NET_9 10k
R10 N1 LABEL_NET_4 10k
R11 N0 N10 10k
R12 N4 N13 10k

.control
set filetype=ascii

op
let power_dc = abs(i(VLABEL_NET_0)) * 1.8
print power_dc
let dc_voltage = v(N0)
print dc_voltage

quit
.endc

.end
