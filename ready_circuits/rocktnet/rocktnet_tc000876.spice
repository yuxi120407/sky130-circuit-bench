* Testcase 000876 — Full Analysis (sky130 tt corner)
* SKY130 model header — replaces the ideal level-1 .model cards
* Ships with the demo; the paths point at the local sky130 PDK checkout.
* NOTE: libs.tech/ngspice/all.spice sets ".option scale=1.0u", so every
* instance L/W below is written in microns WITHOUT a "u" suffix.
.param mc_mm_switch=0
.param mc_pr_switch=0
.include /home/idies/workspace/Temporary/xyu1/scratch/skywater-pdk-libs-sky130_fd_pr/models/corners/tt.spice
.include /home/idies/workspace/Temporary/xyu1/scratch/skywater-pdk-libs-sky130_fd_pr/models/r+c/res_typical__cap_typical.spice
.include /home/idies/workspace/Temporary/xyu1/scratch/skywater-pdk-libs-sky130_fd_pr/models/r+c/res_typical__cap_typical__lin.spice
.include /home/idies/workspace/Temporary/xyu1/scratch/skywater-pdk-libs-sky130_fd_pr/models/corners/tt/specialized_cells.spice
.model DIDEAL D   is=1e-14 n=1
.options reltol=1e-3 itl1=500 itl2=100

* Sources
VVDD VDD 0 1.8
VVIN2 VIN2 0 DC 0.9 AC 1 SIN(0.9 0.1 1MEG 0 0)
VVIN1 VIN1 0 DC 0.9 AC 1 SIN(0.9 0.1 1MEG 0 0)
VVB2 VB2 0 0.9900000000000001
VVB1 VB1 0 0.9900000000000001
VVB3 VB3 0 0.54

* Circuit
XM2 N4 VIN2 N2 VDD sky130_fd_pr__pfet_01v8 l=0.5 w=5
XM1 N0 VIN1 N2 VDD sky130_fd_pr__pfet_01v8 l=0.5 w=5
XM3 VOUT1 VB2 N10 VDD sky130_fd_pr__pfet_01v8 l=0.5 w=5
XM4 N4 CMFB GND GND sky130_fd_pr__nfet_01v8 l=0.5 w=5
XM5 N0 CMFB GND GND sky130_fd_pr__nfet_01v8 l=0.5 w=5
XM6 N7 VB1 VDD VDD sky130_fd_pr__pfet_01v8 l=0.5 w=5
XM7 VOUT2 VB2 N7 VDD sky130_fd_pr__pfet_01v8 l=0.5 w=5
XM8 VOUT2 VB3 N4 GND sky130_fd_pr__nfet_01v8 l=0.5 w=5
XM9 VOUT1 VB3 N0 GND sky130_fd_pr__nfet_01v8 l=0.5 w=5
XM10 N10 VB1 VDD VDD sky130_fd_pr__pfet_01v8 l=0.5 w=5
XM11 N2 VB1 VDD VDD sky130_fd_pr__pfet_01v8 l=0.5 w=5

.control
set filetype=ascii

op
let vdd_current = abs(i(VVDD))
let power_dc = vdd_current * 1.8
print power_dc

print all

quit
.endc

.end
