* Testcase 001117 — Full Analysis (sky130 tt corner)
* SKY130 model header — replaces the ideal level-1 .model cards
* Ships with the demo; the paths point at the local sky130 PDK checkout.
* NOTE: libs.tech/ngspice/all.spice sets ".option scale=1.0u", so every
* instance L/W below is written in microns WITHOUT a "u" suffix.
.param mc_mm_switch=0
.param mc_pr_switch=0
.include /home/idies/workspace/Temporary/xyu1/scratch/skywater-pdk-libs-sky130_fd_pr/models/corners/tt.spice
.include /home/idies/workspace/Temporary/xyu1/scratch/skywater-pdk-libs-sky130_fd_pr/models/r+c/res_typical__cap_typical.spice
.include /home/idies/workspace/Temporary/xyu1/scratch/skywater-pdk-libs-sky130_fd_pr/models/r+c/res_typical__cap_typical__lin.spice
.include /home/idies/workspace/Temporary/xyu1/scratch/skywater-pdk-libs-sky130_fd_pr/models/corners/tt/specialized_cells.spice
.model DIDEAL D   is=1e-14 n=1
.options reltol=1e-3 itl1=500 itl2=100

* Sources
VVBIAS VBIAS 0 DC 0.75 AC 0.5

* Circuit
XQ1 N20 VBIAS N22 0 sky130_fd_pr__npn_05v5_W1p00L1p00
XQ2 VCC N9 OUT 0 sky130_fd_pr__npn_05v5_W1p00L1p00
R6 N19 GND 10k
XQ3 N9 N5 N16 0 sky130_fd_pr__npn_05v5_W1p00L1p00
XQ5 N12 N23 N19 0 sky130_fd_pr__npn_05v5_W1p00L1p00
R2 N22 GND 10k
XQ4 VCC N18 N11 0 sky130_fd_pr__npn_05v5_W1p00L1p00
XQ6 VCC N8 OUTX 0 sky130_fd_pr__npn_05v5_W1p00L1p00
XQ7 OUTX N15 N0 0 sky130_fd_pr__npn_05v5_W1p00L1p00
XQ8 N2 N21 N13 0 sky130_fd_pr__npn_05v5_W1p00L1p00
R3 VCC N20 10k
R4 N14 GND 10k
R5 VCC N9 10k
R10 N11 GND 10k
R7 N13 GND 10k
XQ9 N16 N10 N14 0 sky130_fd_pr__npn_05v5_W1p00L1p00
R9 N15 GND 10k
R8 N0 GND 10k
XQ10 N8 N4 N16 0 sky130_fd_pr__npn_05v5_W1p00L1p00
XQ11 OUT N14 N15 0 sky130_fd_pr__npn_05v5_W1p00L1p00
R1 N5 VCC 10k
XQ12 VCC N1 N12 0 sky130_fd_pr__npn_05v5_W1p00L1p00
R11 VCC N8 10k
XQ13 VCC N3 N2 0 sky130_fd_pr__npn_05v5_W1p00L1p00
R12 N3 N20 10k
C1 N1 N3 1p
R13 N4 VCC 10k
R14 N1 N20 10k
C2 N3 N1 1p
C3 N2 N5 1p
C4 N1 GND 1p
C5 N3 GND 1p
C6 N4 N12 1p

.control
set filetype=ascii

op
let vdd_current = abs(i(VVDD))
let power_dc = vdd_current * 1.8
print power_dc

ac dec 100 1 10g
let vout_mag = vm(OUT)
let gain_db = db(vout_mag)
let dc_gain_db = gain_db[0]
print dc_gain_db

if dc_gain_db > 0
    meas ac ugbw WHEN gain_db=0 CROSS=1
end

quit
.endc

.end
