* Testcase 000867 — Full Analysis (sky130 tt corner)
* SKY130 model header — replaces the ideal level-1 .model cards
* Ships with the demo; the paths point at the local sky130 PDK checkout.
* NOTE: libs.tech/ngspice/all.spice sets ".option scale=1.0u", so every
* instance L/W below is written in microns WITHOUT a "u" suffix.
.param mc_mm_switch=0
.param mc_pr_switch=0
.include /home/idies/workspace/Temporary/xyu1/scratch/skywater-pdk-libs-sky130_fd_pr/models/corners/tt.spice
.include /home/idies/workspace/Temporary/xyu1/scratch/skywater-pdk-libs-sky130_fd_pr/models/r+c/res_typical__cap_typical.spice
.include /home/idies/workspace/Temporary/xyu1/scratch/skywater-pdk-libs-sky130_fd_pr/models/r+c/res_typical__cap_typical__lin.spice
.include /home/idies/workspace/Temporary/xyu1/scratch/skywater-pdk-libs-sky130_fd_pr/models/corners/tt/specialized_cells.spice
.model DIDEAL D   is=1e-14 n=1
.options reltol=1e-3 itl1=500 itl2=100

* Sources
VLABEL_NET_0 LABEL_NET_0 0 DC 0.9 AC 0.5
VLABEL_NET_1 LABEL_NET_1 0 DC 0.9 AC -0.5
VLABEL_NET_2 LABEL_NET_2 0 0.9
VLABEL_NET_3 LABEL_NET_3 0 0.9
VLABEL_NET_4 LABEL_NET_4 0 0.9
VLABEL_NET_5 LABEL_NET_5 0 0.9
VLABEL_NET_6 LABEL_NET_6 0 0.9
VLABEL_NET_7 LABEL_NET_7 0 0.9
VLABEL_NET_8 LABEL_NET_8 0 0.9
VLABEL_NET_9 LABEL_NET_9 0 0.9

* Circuit
R1 N9 N10 10k
XM1 N3 N9 N1 GND sky130_fd_pr__nfet_01v8 l=0.5 w=5
XM2 N2 LABEL_NET_0 N8 GND sky130_fd_pr__nfet_01v8 l=0.5 w=5
R2 N4 N5 10k
XM3 N4 N0 N1 GND sky130_fd_pr__nfet_01v8 l=0.5 w=5
R3 N0 N10 10k
XM4 N7 LABEL_NET_1 N8 GND sky130_fd_pr__nfet_01v8 l=0.5 w=5
R4 N3 N10 10k
R5 N10 N12 10k
R6 N10 N11 10k
XM5 N11 LABEL_NET_2 N7 GND sky130_fd_pr__nfet_01v8 l=0.5 w=5
XM6 N11 LABEL_NET_3 N2 GND sky130_fd_pr__nfet_01v8 l=0.5 w=5
XM7 N0 LABEL_NET_4 N6 GND sky130_fd_pr__nfet_01v8 l=0.5 w=5
XM8 N12 LABEL_NET_5 N2 GND sky130_fd_pr__nfet_01v8 l=0.5 w=5
XM9 N1 GND GND GND sky130_fd_pr__nfet_01v8 l=0.5 w=5
XM10 N11 LABEL_NET_6 N7 GND sky130_fd_pr__nfet_01v8 l=0.5 w=5
XM11 N9 LABEL_NET_7 N6 GND sky130_fd_pr__nfet_01v8 l=0.5 w=5
XM12 N6 LABEL_NET_8 GND GND sky130_fd_pr__nfet_01v8 l=0.5 w=5
XM13 N8 LABEL_NET_9 GND GND sky130_fd_pr__nfet_01v8 l=0.5 w=5
L1 N5 N10 10n

.control
set filetype=ascii

op
let power_dc = abs(i(VLABEL_NET_0)) * 1.8
print power_dc
let dc_voltage = v(N0)
print dc_voltage

quit
.endc

.end
