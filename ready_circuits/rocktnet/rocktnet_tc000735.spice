* Testcase 000735 — Full Analysis (sky130 tt corner)
* SKY130 model header — replaces the ideal level-1 .model cards
* Ships with the demo; the paths point at the local sky130 PDK checkout.
* NOTE: libs.tech/ngspice/all.spice sets ".option scale=1.0u", so every
* instance L/W below is written in microns WITHOUT a "u" suffix.
.param mc_mm_switch=0
.param mc_pr_switch=0
.include /home/idies/workspace/Temporary/xyu1/scratch/skywater-pdk-libs-sky130_fd_pr/models/corners/tt.spice
.include /home/idies/workspace/Temporary/xyu1/scratch/skywater-pdk-libs-sky130_fd_pr/models/r+c/res_typical__cap_typical.spice
.include /home/idies/workspace/Temporary/xyu1/scratch/skywater-pdk-libs-sky130_fd_pr/models/r+c/res_typical__cap_typical__lin.spice
.include /home/idies/workspace/Temporary/xyu1/scratch/skywater-pdk-libs-sky130_fd_pr/models/corners/tt/specialized_cells.spice
.model DIDEAL D   is=1e-14 n=1
.options reltol=1e-3 itl1=500 itl2=100

* Sources
VVDD VDD 0 1.8
VLABEL_NET_0 LABEL_NET_0 0 DC 0.9 AC 0.5
VLABEL_NET_1 LABEL_NET_1 0 DC 0.9 AC -0.5
VLABEL_NET_2 LABEL_NET_2 0 0.9
VLABEL_NET_3 LABEL_NET_3 0 0.9
VLABEL_NET_4 LABEL_NET_4 0 0.9
VLABEL_NET_5 LABEL_NET_5 0 0.9
VLABEL_NET_6 LABEL_NET_6 0 0.9
VLABEL_NET_7 LABEL_NET_7 0 0.9
VLABEL_NET_9 LABEL_NET_9 0 0.9
VLABEL_NET_8 LABEL_NET_8 0 0.9
VLABEL_NET_10 LABEL_NET_10 0 0.9
VLABEL_NET_11 LABEL_NET_11 0 0.9
VLABEL_NET_12 LABEL_NET_12 0 0.9
VLABEL_NET_13 LABEL_NET_13 0 0.9
VLABEL_NET_14 LABEL_NET_14 0 0.9
VLABEL_NET_15 LABEL_NET_15 0 0.9
VLABEL_NET_17 LABEL_NET_17 0 0.9
VLABEL_NET_16 LABEL_NET_16 0 0.9
VLABEL_NET_18 LABEL_NET_18 0 0.9
VLABEL_NET_19 LABEL_NET_19 0 0.9
VLABEL_NET_20 LABEL_NET_20 0 0.9
VLABEL_NET_21 LABEL_NET_21 0 0.9

* Circuit
XM6 N5 LABEL_NET_0 VOUT VDD sky130_fd_pr__pfet_01v8 l=0.5 w=5
XM5 N6 LABEL_NET_1 N5 VDD sky130_fd_pr__pfet_01v8 l=0.5 w=5
XM4 N0 LABEL_NET_2 VOUT VDD sky130_fd_pr__pfet_01v8 l=0.5 w=5
XM12 N6 LABEL_NET_3 N3 VDD sky130_fd_pr__pfet_01v8 l=0.5 w=5
XM1 N7 VOUT VOUT VDD sky130_fd_pr__pfet_01v8 l=0.5 w=5
XM3 N0 LABEL_NET_4 N0 VDD sky130_fd_pr__pfet_01v8 l=0.5 w=5
XM2 N3 LABEL_NET_5 VOUT VDD sky130_fd_pr__pfet_01v8 l=0.5 w=5
CEXT1 N0 N3 1p
XM7 N1 LABEL_NET_6 N1 VDD sky130_fd_pr__pfet_01v8 l=0.5 w=5
XM11 N7 LABEL_NET_7 N7 VDD sky130_fd_pr__pfet_01v8 l=0.5 w=5
XM21 N0 LABEL_NET_9 LABEL_NET_8 GND sky130_fd_pr__nfet_01v8 l=0.5 w=5
XM10 N4 LABEL_NET_10 VOUT VDD sky130_fd_pr__pfet_01v8 l=0.5 w=5
XM16 N0 LABEL_NET_8 N5 GND sky130_fd_pr__nfet_01v8 l=0.5 w=5
XM9 N6 LABEL_NET_11 N4 VDD sky130_fd_pr__pfet_01v8 l=0.5 w=5
XM18 N1 LABEL_NET_12 N4 GND sky130_fd_pr__nfet_01v8 l=0.5 w=5
CEXT2 N1 N5 1p
XM15 N0 LABEL_NET_13 N5 GND sky130_fd_pr__nfet_01v8 l=0.5 w=5
XM8 N1 LABEL_NET_14 VOUT VDD sky130_fd_pr__pfet_01v8 l=0.5 w=5
XM17 N1 LABEL_NET_15 LABEL_NET_11 GND sky130_fd_pr__nfet_01v8 l=0.5 w=5
CEXT3 N4 N7 1p
XM20 N7 LABEL_NET_17 LABEL_NET_16 GND sky130_fd_pr__nfet_01v8 l=0.5 w=5
XM19 N1 LABEL_NET_18 N4 GND sky130_fd_pr__nfet_01v8 l=0.5 w=5
XM13 N3 LABEL_NET_19 N3 GND sky130_fd_pr__nfet_01v8 l=0.5 w=5
XM14 N3 LABEL_NET_20 N0 GND sky130_fd_pr__nfet_01v8 l=0.5 w=5
CHOLD VOUT LABEL_NET_21 1p

.control
set filetype=ascii

op
let vdd_current = abs(i(VVDD))
let power_dc = vdd_current * 1.8
print power_dc

ac dec 100 1 10g
let vout_mag = vm(VOUT)
let gain_db = db(vout_mag)
let dc_gain_db = gain_db[0]
print dc_gain_db

if dc_gain_db > 0
    meas ac ugbw WHEN gain_db=0 CROSS=1
end

quit
.endc

.end
