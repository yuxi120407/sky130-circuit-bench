* Testcase 000178 — Full Analysis (sky130 tt corner)
* SKY130 model header — replaces the ideal level-1 .model cards
* Ships with the demo; the paths point at the local sky130 PDK checkout.
* NOTE: libs.tech/ngspice/all.spice sets ".option scale=1.0u", so every
* instance L/W below is written in microns WITHOUT a "u" suffix.
.param mc_mm_switch=0
.param mc_pr_switch=0
.include /home/idies/workspace/Temporary/xyu1/scratch/skywater-pdk-libs-sky130_fd_pr/models/corners/tt.spice
.include /home/idies/workspace/Temporary/xyu1/scratch/skywater-pdk-libs-sky130_fd_pr/models/r+c/res_typical__cap_typical.spice
.include /home/idies/workspace/Temporary/xyu1/scratch/skywater-pdk-libs-sky130_fd_pr/models/r+c/res_typical__cap_typical__lin.spice
.include /home/idies/workspace/Temporary/xyu1/scratch/skywater-pdk-libs-sky130_fd_pr/models/corners/tt/specialized_cells.spice
.model DIDEAL D   is=1e-14 n=1
.options reltol=1e-3 itl1=500 itl2=100

* Sources
VVDD VDD 0 1.8
VVBIAS VBIAS 0 0.54
VVINn VINn 0 DC 0.9 AC 1 SIN(0.9 0.1 1MEG 0 0)
VVINp VINp 0 DC 0.9 AC 1 SIN(0.9 0.1 1MEG 0 0)
VVINJn VINJn 0 DC 0.9 AC 1 SIN(0.9 0.1 1MEG 0 0)
VVINJp VINJp 0 DC 0.9 AC 1 SIN(0.9 0.1 1MEG 0 0)

* Circuit
XM1 N_E3 VBIAS GND GND sky130_fd_pr__nfet_01v8 l=0.5 w=5
XM2 VOUTp VBIAS GND GND sky130_fd_pr__nfet_01v8 l=0.5 w=5
XM3 N_M3D VBIAS GND GND sky130_fd_pr__nfet_01v8 l=0.5 w=5
XM4 VOUTn VBIAS GND GND sky130_fd_pr__nfet_01v8 l=0.5 w=5
XM5 N_E5 VBIAS GND GND sky130_fd_pr__nfet_01v8 l=0.5 w=5
XQ1 N_R2 VINn N_E21 0 sky130_fd_pr__npn_05v5_W1p00L1p00
XQ2 N_R3 VINp N_E21 0 sky130_fd_pr__npn_05v5_W1p00L1p00
XQ3 N_R3 VINJn N_E3 0 sky130_fd_pr__npn_05v5_W1p00L1p00
XQ4 VDD N_R3 VOUTp 0 sky130_fd_pr__npn_05v5_W1p00L1p00
XQ5 N_R2 VINJp N_E5 0 sky130_fd_pr__npn_05v5_W1p00L1p00
XQ6 VDD N_R2 VOUTn 0 sky130_fd_pr__npn_05v5_W1p00L1p00
R1 N_E21 N_M3D 10k
R2 VDD N_R2 10k
R3 VDD N_R3 10k
R4 N_E5 N_E3 10k

.control
set filetype=ascii

op
let vdd_current = abs(i(VVDD))
let power_dc = vdd_current * 1.8
print power_dc

print all

quit
.endc

.end
