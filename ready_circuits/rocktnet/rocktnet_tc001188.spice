* Testcase 001188 — Full Analysis (sky130 tt corner)
* SKY130 model header — replaces the ideal level-1 .model cards
* Ships with the demo; the paths point at the local sky130 PDK checkout.
* NOTE: libs.tech/ngspice/all.spice sets ".option scale=1.0u", so every
* instance L/W below is written in microns WITHOUT a "u" suffix.
.param mc_mm_switch=0
.param mc_pr_switch=0
.include /home/idies/workspace/Temporary/xyu1/scratch/skywater-pdk-libs-sky130_fd_pr/models/corners/tt.spice
.include /home/idies/workspace/Temporary/xyu1/scratch/skywater-pdk-libs-sky130_fd_pr/models/r+c/res_typical__cap_typical.spice
.include /home/idies/workspace/Temporary/xyu1/scratch/skywater-pdk-libs-sky130_fd_pr/models/r+c/res_typical__cap_typical__lin.spice
.include /home/idies/workspace/Temporary/xyu1/scratch/skywater-pdk-libs-sky130_fd_pr/models/corners/tt/specialized_cells.spice
.model DIDEAL D   is=1e-14 n=1
.options reltol=1e-3 itl1=500 itl2=100

* Sources
VVDD VDD 0 1.8
VLABEL_NET_0 LABEL_NET_0 0 DC 0.9 AC 0.5
VLABEL_NET_1 LABEL_NET_1 0 DC 0.9 AC -0.5
VLABEL_NET_2 LABEL_NET_2 0 0.9

* Circuit
L1 N1 GND 10n
XM1 N5 N0 N7 GND sky130_fd_pr__nfet_01v8 l=0.5 w=5
R1 N0 VDD 10k
L2 VDD LABEL_NET_0 10n
XM2 LABEL_NET_0 N0 N8 GND sky130_fd_pr__nfet_01v8 l=0.5 w=5
L3 N4 GND 10n
L4 VDD N5 10n
C1 N2 LABEL_NET_1 1p
XM3 N7 N9 N4 GND sky130_fd_pr__nfet_01v8 l=0.5 w=5
XM4 N8 N2 N1 GND sky130_fd_pr__nfet_01v8 l=0.5 w=5
R2 N2 BIAS 10k
R3 BIAS N9 10k
C2 N9 LABEL_NET_2 1p

.control
set filetype=ascii

op
let power_dc = abs(i(VVDD)) * 1.8
print power_dc

ac dec 100 1 10g
let vout_mag = vm(BIAS)
let gain_db = db(vout_mag)
let dc_gain_db = gain_db[0]
print dc_gain_db

if dc_gain_db > 0
    meas ac ugbw WHEN gain_db=0 CROSS=1
    print ugbw
end

quit
.endc

.end
