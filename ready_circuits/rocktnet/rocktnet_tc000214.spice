* Testcase 000214 — Full Analysis (sky130 tt corner)
* SKY130 model header — replaces the ideal level-1 .model cards
* Ships with the demo; the paths point at the local sky130 PDK checkout.
* NOTE: libs.tech/ngspice/all.spice sets ".option scale=1.0u", so every
* instance L/W below is written in microns WITHOUT a "u" suffix.
.param mc_mm_switch=0
.param mc_pr_switch=0
.include /home/idies/workspace/Temporary/xyu1/scratch/skywater-pdk-libs-sky130_fd_pr/models/corners/tt.spice
.include /home/idies/workspace/Temporary/xyu1/scratch/skywater-pdk-libs-sky130_fd_pr/models/r+c/res_typical__cap_typical.spice
.include /home/idies/workspace/Temporary/xyu1/scratch/skywater-pdk-libs-sky130_fd_pr/models/r+c/res_typical__cap_typical__lin.spice
.include /home/idies/workspace/Temporary/xyu1/scratch/skywater-pdk-libs-sky130_fd_pr/models/corners/tt/specialized_cells.spice
.model DIDEAL D   is=1e-14 n=1
.options reltol=1e-3 itl1=500 itl2=100

* Sources
VVDD VDD 0 1.8

* Circuit
XM14 N24 N12 VCC VDD sky130_fd_pr__pfet_01v8 l=0.5 w=5
XM2 N9 N15 N21 VDD sky130_fd_pr__pfet_01v8 l=0.5 w=5
I1 N15 GND 1u
XM3 N10 N10 N17 VDD sky130_fd_pr__pfet_01v8 l=0.5 w=5
XM4 N1 N10 N16 VDD sky130_fd_pr__pfet_01v8 l=0.5 w=5
XM5 N21 N12 VCC VDD sky130_fd_pr__pfet_01v8 l=0.5 w=5
XM6 N19 N17 VCC VDD sky130_fd_pr__pfet_01v8 l=0.5 w=5
I2 N10 GND 1u
XM7 N17 N17 VCC VDD sky130_fd_pr__pfet_01v8 l=0.5 w=5
XM8 N27 N15 N24 VDD sky130_fd_pr__pfet_01v8 l=0.5 w=5
R5 VO GND 10k
XM9 N12 N12 VCC VDD sky130_fd_pr__pfet_01v8 l=0.5 w=5
C5 N6 N9 1p
XM10 N17 N25 N19 VDD sky130_fd_pr__pfet_01v8 l=0.5 w=5
XM11 N8 N27 GND GND sky130_fd_pr__nfet_01v8 l=0.5 w=5
XM12 N16 N17 VCC VDD sky130_fd_pr__pfet_01v8 l=0.5 w=5
C4 N8 N22 1p
R2 N6 N7 10k
XM13 N15 N15 N12 VDD sky130_fd_pr__pfet_01v8 l=0.5 w=5
R3 N0 GND 10k
XQ6 N20 N20 N5 0 sky130_fd_pr__npn_05v5_W1p00L1p00
XQ2 N1 N8 GND 0 sky130_fd_pr__npn_05v5_W1p00L1p00
R4 VCC N7 10k
XM1 N8 N0 N1 VDD sky130_fd_pr__pfet_01v8 l=0.5 w=5
CX N11 GND 1p
R1 VCC N13 10k
XQ3 N7 N7 GND 0 sky130_fd_pr__npn_05v5_W1p00L1p00
R6 N0 N3 10k
RX N8 N11 10k
XQ1 N9 N22 GND 0 sky130_fd_pr__npn_05v5_W1p00L1p00
XQ4 N26 N6 VO 0 sky130_fd_pr__npn_05v5_W1p00L1p00
XQ8 VCC N13 N3 0 sky130_fd_pr__npn_05v5_W1p00L1p00
XQ7 VCC VCC N20 0 sky130_fd_pr__npn_05v5_W1p00L1p00
C1 N9 GND 1p
C6 VO GND 1p
CC N1 GND 1p
L N9 N22 10n
XQ5 N5 N5 N26 0 sky130_fd_pr__npn_05v5_W1p00L1p00
XM15 N27 N27 GND GND sky130_fd_pr__nfet_01v8 l=0.5 w=5
XQ9 N13 N3 GND 0 sky130_fd_pr__npn_05v5_W1p00L1p00

.control
set filetype=ascii

op
let vdd_current = abs(i(VVDD))
let power_dc = vdd_current * 1.8
print power_dc

ac dec 100 1k 100g
let vout_mag = vm(VO)
let gain_db = db(vout_mag)

meas ac max_gain_db MAX gain_db
meas ac bw_3db WHEN gain_db='max_gain_db-3' CROSS=1

print max_gain_db bw_3db

quit
.endc

.end
