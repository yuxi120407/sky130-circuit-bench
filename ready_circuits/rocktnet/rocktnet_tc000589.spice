* Testcase 000589 — Full Analysis (sky130 tt corner)
* SKY130 model header — replaces the ideal level-1 .model cards
* Ships with the demo; the paths point at the local sky130 PDK checkout.
* NOTE: libs.tech/ngspice/all.spice sets ".option scale=1.0u", so every
* instance L/W below is written in microns WITHOUT a "u" suffix.
.param mc_mm_switch=0
.param mc_pr_switch=0
.include /home/idies/workspace/Temporary/xyu1/scratch/skywater-pdk-libs-sky130_fd_pr/models/corners/tt.spice
.include /home/idies/workspace/Temporary/xyu1/scratch/skywater-pdk-libs-sky130_fd_pr/models/r+c/res_typical__cap_typical.spice
.include /home/idies/workspace/Temporary/xyu1/scratch/skywater-pdk-libs-sky130_fd_pr/models/r+c/res_typical__cap_typical__lin.spice
.include /home/idies/workspace/Temporary/xyu1/scratch/skywater-pdk-libs-sky130_fd_pr/models/corners/tt/specialized_cells.spice
.model DIDEAL D   is=1e-14 n=1
.options reltol=1e-3 itl1=500 itl2=100

* Sources
VVDD VDD 0 1.8
VVCONTROL VCONTROL 0 0.9

* Circuit
I1 VDD NET1 1u
R1 NET1 GND 10k
XM1 NET3 NET2 NET4 GND sky130_fd_pr__nfet_01v8 l=0.5 w=5
R2 NET4 GND 10k
R3 VDD NET3 10k

.control
set filetype=ascii

op
let power_dc = abs(i(VVDD)) * 1.8
print power_dc
let dc_voltage_10k = v(10k)
print dc_voltage_10k
let dc_voltage_NET1 = v(NET1)
print dc_voltage_NET1
let dc_voltage_NET2 = v(NET2)
print dc_voltage_NET2
let dc_voltage_NET3 = v(NET3)
print dc_voltage_NET3
let dc_voltage_NET4 = v(NET4)
print dc_voltage_NET4

quit
.endc

.end
