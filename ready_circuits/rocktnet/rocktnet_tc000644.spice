* Testcase 000644 — Full Analysis (sky130 tt corner)
* SKY130 model header — replaces the ideal level-1 .model cards
* Ships with the demo; the paths point at the local sky130 PDK checkout.
* NOTE: libs.tech/ngspice/all.spice sets ".option scale=1.0u", so every
* instance L/W below is written in microns WITHOUT a "u" suffix.
.param mc_mm_switch=0
.param mc_pr_switch=0
.include /home/idies/workspace/Temporary/xyu1/scratch/skywater-pdk-libs-sky130_fd_pr/models/corners/tt.spice
.include /home/idies/workspace/Temporary/xyu1/scratch/skywater-pdk-libs-sky130_fd_pr/models/r+c/res_typical__cap_typical.spice
.include /home/idies/workspace/Temporary/xyu1/scratch/skywater-pdk-libs-sky130_fd_pr/models/r+c/res_typical__cap_typical__lin.spice
.include /home/idies/workspace/Temporary/xyu1/scratch/skywater-pdk-libs-sky130_fd_pr/models/corners/tt/specialized_cells.spice
.model DIDEAL D   is=1e-14 n=1
.options reltol=1e-3 itl1=500 itl2=100

* Sources
VLABEL_NET_0 LABEL_NET_0 0 0.9

* Circuit
I1 N0 VEE 1u
I2 N2 VEE 1u
XQ1 GND N6 N2 0 sky130_fd_pr__npn_05v5_W1p00L1p00
XQ2 GND N2 DATA_OUT 0 sky130_fd_pr__npn_05v5_W1p00L1p00
XQ3 N10 N5 N5 0 sky130_fd_pr__npn_05v5_W1p00L1p00
XQ4 N7 DATA_OUT N8 0 sky130_fd_pr__npn_05v5_W1p00L1p00
XQ5 GND N10 N0 0 sky130_fd_pr__npn_05v5_W1p00L1p00
XQ6 N8 LABEL_NET_0 N4 0 sky130_fd_pr__npn_05v5_W1p00L1p00
XQ7 N6 DATA_IN N5 0 sky130_fd_pr__npn_05v5_W1p00L1p00
R2 N7 N10 10k
I3 N1 VEE 1u
I4 DATA_OUT VEE 1u
XQ8 GND N0 N1 0 sky130_fd_pr__npn_05v5_W1p00L1p00
XQ9 N9 N1 N8 0 sky130_fd_pr__npn_05v5_W1p00L1p00
I5 N4 VEE 1u
XQ10 N5 CLOCK N4 0 sky130_fd_pr__npn_05v5_W1p00L1p00
R3 N6 N9 10k
R1 N7 GND 10k
R4 N9 GND 10k

.control
set filetype=ascii

op
let power_dc = abs(i(VLABEL_NET_0)) * 1.8
print power_dc

tran 0.1n 100n

let power = abs(i(VVDD)) * 1.8
let avg_power = mean(power)
print avg_power

meas tran vout_max MAX v(N7)
meas tran vout_min MIN v(N7)
let vout_swing = vout_max - vout_min
print vout_swing

quit
.endc

.end
