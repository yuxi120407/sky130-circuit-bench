* Testcase 001248 — Full Analysis (sky130 tt corner)
* SKY130 model header — replaces the ideal level-1 .model cards
* Ships with the demo; the paths point at the local sky130 PDK checkout.
* NOTE: libs.tech/ngspice/all.spice sets ".option scale=1.0u", so every
* instance L/W below is written in microns WITHOUT a "u" suffix.
.param mc_mm_switch=0
.param mc_pr_switch=0
.include /home/idies/workspace/Temporary/xyu1/scratch/skywater-pdk-libs-sky130_fd_pr/models/corners/tt.spice
.include /home/idies/workspace/Temporary/xyu1/scratch/skywater-pdk-libs-sky130_fd_pr/models/r+c/res_typical__cap_typical.spice
.include /home/idies/workspace/Temporary/xyu1/scratch/skywater-pdk-libs-sky130_fd_pr/models/r+c/res_typical__cap_typical__lin.spice
.include /home/idies/workspace/Temporary/xyu1/scratch/skywater-pdk-libs-sky130_fd_pr/models/corners/tt/specialized_cells.spice
.model DIDEAL D   is=1e-14 n=1
.options reltol=1e-2 abstol=1e-10 vntol=1e-4 itl1=1000 itl2=200 itl4=100
.options gmin=1e-10 method=gear

* Sources
VVDD VDD 0 1.8

* Circuit
XM1 N8 N1 VDD VDD sky130_fd_pr__pfet_01v8 l=0.5 w=5
XM4 N3 N1 GND GND sky130_fd_pr__nfet_01v8 l=0.5 w=5
XM6 N7 N3 GND GND sky130_fd_pr__nfet_01v8 l=0.5 w=5
XM7 GND VG7 N0 VDD sky130_fd_pr__pfet_01v8 l=0.5 w=5
XM2 N1 N8 VDD VDD sky130_fd_pr__pfet_01v8 l=0.5 w=5
XM3 N4 N8 GND GND sky130_fd_pr__nfet_01v8 l=0.5 w=5
XM5 N2 N4 GND GND sky130_fd_pr__nfet_01v8 l=0.5 w=5
CB2 N0 GND 1p
L1 N0 N8 10n
CB1 VCTL GND 1p
L2 N0 N1 10n
L3 N4 VDD_A 10n
L5 N2 VDD_A 10n
L4 VDD N3 10n
L6 VDD N7 10n
CV2 N1 VCTL 1p
CV1 VCTL N8 1p

.control
set filetype=ascii

op
let power_dc = abs(i(VVDD)) * 1.8
print power_dc
let dc_voltage = v(N0)
print dc_voltage
print all

quit
.endc

.end
