* Testcase 000862 — Full Analysis (sky130 tt corner)
* SKY130 model header — replaces the ideal level-1 .model cards
* Ships with the demo; the paths point at the local sky130 PDK checkout.
* NOTE: libs.tech/ngspice/all.spice sets ".option scale=1.0u", so every
* instance L/W below is written in microns WITHOUT a "u" suffix.
.param mc_mm_switch=0
.param mc_pr_switch=0
.include /home/idies/workspace/Temporary/xyu1/scratch/skywater-pdk-libs-sky130_fd_pr/models/corners/tt.spice
.include /home/idies/workspace/Temporary/xyu1/scratch/skywater-pdk-libs-sky130_fd_pr/models/r+c/res_typical__cap_typical.spice
.include /home/idies/workspace/Temporary/xyu1/scratch/skywater-pdk-libs-sky130_fd_pr/models/r+c/res_typical__cap_typical__lin.spice
.include /home/idies/workspace/Temporary/xyu1/scratch/skywater-pdk-libs-sky130_fd_pr/models/corners/tt/specialized_cells.spice
.model DIDEAL D   is=1e-14 n=1
.options reltol=1e-3 itl1=500 itl2=100

* Sources
VLABEL_NET_0 LABEL_NET_0 0 0.9
VLABEL_NET_2 LABEL_NET_2 0 0.9
VLABEL_NET_3 LABEL_NET_3 0 0.9
VVIN VIN 0 DC 0.9 AC 1 SIN(0.9 0.1 1MEG 0 0)

* Circuit
R1 N7 GND 10k
R2 N0 N1 10k
C1 N5 GND 1p
C2 N6 GND 1p
R3 N0 N3 10k
C3 N7 GND 1p
R4 GND GND 10k
C4 N12 GND 1p
R5 VIN VIN 10k
R6 N4 N8 10k
C5 N0 N8 1p
R7 N1 N5 10k
R8 GND GND 10k
R9 N10 N12 10k
R10 N4 GND 10k
C6 N11 GND 1p
R11 N5 N8 10k
R12 N2 N6 10k
R13 N9 GND 10k
R14 N7 VIN 10k
R15 N3 N6 10k
R16 N2 N10 10k
C7 N3 N10 1p
R17 N11 GND 10k
R18 N11 N12 10k

.control
set filetype=ascii

op
let power_dc = abs(i(VLABEL_NET_0)) * 1.8
print power_dc

ac dec 100 1 10g
let vout_mag = vm(N7)
let gain_db = db(vout_mag)

meas ac max_gain_db MAX gain_db
meas ac bw_3db WHEN gain_db='max_gain_db-3' CROSS=1

print max_gain_db bw_3db

quit
.endc

.end
