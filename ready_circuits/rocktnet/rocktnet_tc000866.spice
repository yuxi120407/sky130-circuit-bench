* Testcase 000866 — Full Analysis (sky130 tt corner)
* SKY130 model header — replaces the ideal level-1 .model cards
* Ships with the demo; the paths point at the local sky130 PDK checkout.
* NOTE: libs.tech/ngspice/all.spice sets ".option scale=1.0u", so every
* instance L/W below is written in microns WITHOUT a "u" suffix.
.param mc_mm_switch=0
.param mc_pr_switch=0
.include /home/idies/workspace/Temporary/xyu1/scratch/skywater-pdk-libs-sky130_fd_pr/models/corners/tt.spice
.include /home/idies/workspace/Temporary/xyu1/scratch/skywater-pdk-libs-sky130_fd_pr/models/r+c/res_typical__cap_typical.spice
.include /home/idies/workspace/Temporary/xyu1/scratch/skywater-pdk-libs-sky130_fd_pr/models/r+c/res_typical__cap_typical__lin.spice
.include /home/idies/workspace/Temporary/xyu1/scratch/skywater-pdk-libs-sky130_fd_pr/models/corners/tt/specialized_cells.spice
.model DIDEAL D   is=1e-14 n=1
.options reltol=1e-3 itl1=500 itl2=100

* Sources
VVDD VDD 0 1.8
VLABEL_NET_0 LABEL_NET_0 0 DC 0.9 AC 0.5
VLABEL_NET_1 LABEL_NET_1 0 DC 0.9 AC -0.5
VLABEL_NET_2 LABEL_NET_2 0 0.9
VLABEL_NET_3 LABEL_NET_3 0 0.9
VLABEL_NET_4 LABEL_NET_4 0 0.9
VLABEL_NET_5 LABEL_NET_5 0 0.9
VLABEL_NET_6 LABEL_NET_6 0 0.9

* Circuit
XM1 N4 N9 N8 GND sky130_fd_pr__nfet_01v8 l=0.5 w=5
R1 N0 N2 10k
XM2 N9 N4 N8 GND sky130_fd_pr__nfet_01v8 l=0.5 w=5
XM3 N0 LABEL_NET_0 N5 GND sky130_fd_pr__nfet_01v8 l=0.5 w=5
R2 N0 N11 10k
XM4 N4 LABEL_NET_1 N10 GND sky130_fd_pr__nfet_01v8 l=0.5 w=5
XM5 N9 LABEL_NET_2 N10 GND sky130_fd_pr__nfet_01v8 l=0.5 w=5
R3 N4 N12 10k
XM6 N8 N8 N6 GND sky130_fd_pr__nfet_01v8 l=0.5 w=5
XM7 N0 N0 N7 GND sky130_fd_pr__nfet_01v8 l=0.5 w=5
XM8 N0 LABEL_NET_3 N5 GND sky130_fd_pr__nfet_01v8 l=0.5 w=5
R4 N1 N9 10k
XM9 N10 LABEL_NET_4 N6 GND sky130_fd_pr__nfet_01v8 l=0.5 w=5
XM10 N0 N0 N7 GND sky130_fd_pr__nfet_01v8 l=0.5 w=5
XM11 N3 GND GND GND sky130_fd_pr__nfet_01v8 l=0.5 w=5
XM12 N7 LABEL_NET_5 N3 GND sky130_fd_pr__nfet_01v8 l=0.5 w=5
XM13 N5 LABEL_NET_6 N3 GND sky130_fd_pr__nfet_01v8 l=0.5 w=5
XM14 N6 N6 GND GND sky130_fd_pr__nfet_01v8 l=0.5 w=5
L1 N2 N2 10n
L2 VDD N12 10n
L3 VDD N1 10n
L4 VDD N11 10n

.control
set filetype=ascii

op
let power_dc = abs(i(VVDD)) * 1.8
print power_dc

ac dec 100 1 10g
let vout_mag = vm(N10)
let gain_db = db(vout_mag)
let dc_gain_db = gain_db[0]
print dc_gain_db

if dc_gain_db > 0
    meas ac ugbw WHEN gain_db=0 CROSS=1
    print ugbw
end

quit
.endc

.end
