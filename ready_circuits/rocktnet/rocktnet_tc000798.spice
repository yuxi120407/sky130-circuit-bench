* Testcase 000798 — Full Analysis (sky130 tt corner)
* SKY130 model header — replaces the ideal level-1 .model cards
* Ships with the demo; the paths point at the local sky130 PDK checkout.
* NOTE: libs.tech/ngspice/all.spice sets ".option scale=1.0u", so every
* instance L/W below is written in microns WITHOUT a "u" suffix.
.param mc_mm_switch=0
.param mc_pr_switch=0
.include /home/idies/workspace/Temporary/xyu1/scratch/skywater-pdk-libs-sky130_fd_pr/models/corners/tt.spice
.include /home/idies/workspace/Temporary/xyu1/scratch/skywater-pdk-libs-sky130_fd_pr/models/r+c/res_typical__cap_typical.spice
.include /home/idies/workspace/Temporary/xyu1/scratch/skywater-pdk-libs-sky130_fd_pr/models/r+c/res_typical__cap_typical__lin.spice
.include /home/idies/workspace/Temporary/xyu1/scratch/skywater-pdk-libs-sky130_fd_pr/models/corners/tt/specialized_cells.spice
.model DIDEAL D   is=1e-14 n=1
.options reltol=1e-3 itl1=500 itl2=100

* Sources
VVDD VDD 0 1.8
VVB VB 0 DC 0.75 AC 0.5

* Circuit
XM1A N1 VDD VA GND sky130_fd_pr__nfet_01v8 l=0.5 w=5
XM3A VDD N1 N3 GND sky130_fd_pr__nfet_01v8 l=0.5 w=5
XM1B N4 VI_PLUS VB GND sky130_fd_pr__nfet_01v8 l=0.5 w=5
XM2A VA N3 VA GND sky130_fd_pr__nfet_01v8 l=0.5 w=5
I1 N3 GND 1u
I2 VDD N1 1u
I3 VDD N4 1u
XM3B VDD N4 N0 GND sky130_fd_pr__nfet_01v8 l=0.5 w=5
XM2B VB N0 VB GND sky130_fd_pr__nfet_01v8 l=0.5 w=5
I4 N0 GND 1u
R VB VA 10k

.control
set filetype=ascii

op
let power_dc = abs(i(VVDD)) * 1.8
print power_dc

ac dec 100 1 10g
let vout_mag = vm(N4)
let gain_db = db(vout_mag)
let dc_gain_db = gain_db[0]
print dc_gain_db

if dc_gain_db > 0
    meas ac ugbw WHEN gain_db=0 CROSS=1
    print ugbw
end

quit
.endc

.end
