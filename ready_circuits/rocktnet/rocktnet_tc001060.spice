* Testcase 001060 — Full Analysis (sky130 tt corner)
* SKY130 model header — replaces the ideal level-1 .model cards
* Ships with the demo; the paths point at the local sky130 PDK checkout.
* NOTE: libs.tech/ngspice/all.spice sets ".option scale=1.0u", so every
* instance L/W below is written in microns WITHOUT a "u" suffix.
.param mc_mm_switch=0
.param mc_pr_switch=0
.include /home/idies/workspace/Temporary/xyu1/scratch/skywater-pdk-libs-sky130_fd_pr/models/corners/tt.spice
.include /home/idies/workspace/Temporary/xyu1/scratch/skywater-pdk-libs-sky130_fd_pr/models/r+c/res_typical__cap_typical.spice
.include /home/idies/workspace/Temporary/xyu1/scratch/skywater-pdk-libs-sky130_fd_pr/models/r+c/res_typical__cap_typical__lin.spice
.include /home/idies/workspace/Temporary/xyu1/scratch/skywater-pdk-libs-sky130_fd_pr/models/corners/tt/specialized_cells.spice
.model DIDEAL D   is=1e-14 n=1
.options reltol=1e-3 itl1=500 itl2=100

* Sources
VVDD VDD 0 1.8
VVREFHI VREFHI 0 0.9
VVREFLO VREFLO 0 0.9

* Circuit
XM1 V_N V_IN N3 GND sky130_fd_pr__nfet_01v8 l=0.5 w=5
XM2 N4 V_BIASN GND GND sky130_fd_pr__nfet_01v8 l=0.5 w=5
XM3 V_NB VREFHI N3 GND sky130_fd_pr__nfet_01v8 l=0.5 w=5
XM4 V_NB V_IN N2 GND sky130_fd_pr__nfet_01v8 l=0.5 w=5
XM5 N3 GND GND GND sky130_fd_pr__nfet_01v8 l=0.5 w=5
XM6 V_N VREFHI N4 GND sky130_fd_pr__nfet_01v8 l=0.5 w=5
XM7 V_N VREFLO N2 GND sky130_fd_pr__nfet_01v8 l=0.5 w=5
XM8 N2 GND GND GND sky130_fd_pr__nfet_01v8 l=0.5 w=5
R1 VDD V_NB 10k
R2 VDD V_N 10k

.control
set filetype=ascii

op
let vdd_current = abs(i(VVDD))
let power_dc = vdd_current * 1.8
print power_dc

print all

quit
.endc

.end
