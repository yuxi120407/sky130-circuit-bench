* Testcase 000550 — Full Analysis (sky130 tt corner)
* SKY130 model header — replaces the ideal level-1 .model cards
* Ships with the demo; the paths point at the local sky130 PDK checkout.
* NOTE: libs.tech/ngspice/all.spice sets ".option scale=1.0u", so every
* instance L/W below is written in microns WITHOUT a "u" suffix.
.param mc_mm_switch=0
.param mc_pr_switch=0
.include /home/idies/workspace/Temporary/xyu1/scratch/skywater-pdk-libs-sky130_fd_pr/models/corners/tt.spice
.include /home/idies/workspace/Temporary/xyu1/scratch/skywater-pdk-libs-sky130_fd_pr/models/r+c/res_typical__cap_typical.spice
.include /home/idies/workspace/Temporary/xyu1/scratch/skywater-pdk-libs-sky130_fd_pr/models/r+c/res_typical__cap_typical__lin.spice
.include /home/idies/workspace/Temporary/xyu1/scratch/skywater-pdk-libs-sky130_fd_pr/models/corners/tt/specialized_cells.spice
.model DIDEAL D   is=1e-14 n=1
.options reltol=1e-3 itl1=500 itl2=100

* Sources
VVDD VDD 0 1.8
VVIN_P VIN_P 0 DC 0.9 AC 1 SIN(0.9 0.1 1MEG 0 0)
VVIN_N VIN_N 0 DC 0.9 AC 1 SIN(0.9 0.1 1MEG 0 0)

* Circuit
L1 VDD VOUT_L 10n
L2 VDD VOUT_R 10n
C1 N_G1 VOUT_L 1p
C2 VOUT_R N_G2 1p
XM1 N_S1 N_G1 GND GND sky130_fd_pr__nfet_01v8 l=0.5 w=5
XM2 N_S2 N_G2 GND GND sky130_fd_pr__nfet_01v8 l=0.5 w=5
XM3 VOUT_L VIN_P N_S1 GND sky130_fd_pr__nfet_01v8 l=0.5 w=5
XM4 VOUT_L VOUT_R N_S1 GND sky130_fd_pr__nfet_01v8 l=0.5 w=5
XM5 VOUT_R VOUT_L N_S2 GND sky130_fd_pr__nfet_01v8 l=0.5 w=5
XM6 VOUT_R VIN_N N_S2 GND sky130_fd_pr__nfet_01v8 l=0.5 w=5

.control
set filetype=ascii

op
let vdd_current = abs(i(VVDD))
let power_dc = vdd_current * 1.8
print power_dc

print all

quit
.endc

.end
