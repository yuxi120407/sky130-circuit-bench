* Testcase 000965 — Full Analysis (sky130 tt corner)
* SKY130 model header — replaces the ideal level-1 .model cards
* Ships with the demo; the paths point at the local sky130 PDK checkout.
* NOTE: libs.tech/ngspice/all.spice sets ".option scale=1.0u", so every
* instance L/W below is written in microns WITHOUT a "u" suffix.
.param mc_mm_switch=0
.param mc_pr_switch=0
.include /home/idies/workspace/Temporary/xyu1/scratch/skywater-pdk-libs-sky130_fd_pr/models/corners/tt.spice
.include /home/idies/workspace/Temporary/xyu1/scratch/skywater-pdk-libs-sky130_fd_pr/models/r+c/res_typical__cap_typical.spice
.include /home/idies/workspace/Temporary/xyu1/scratch/skywater-pdk-libs-sky130_fd_pr/models/r+c/res_typical__cap_typical__lin.spice
.include /home/idies/workspace/Temporary/xyu1/scratch/skywater-pdk-libs-sky130_fd_pr/models/corners/tt/specialized_cells.spice
.model DIDEAL D   is=1e-14 n=1
.options reltol=1e-3 itl1=500 itl2=100

* Sources
VVDD VDD 0 1.8
VVCMFB VCMFB 0 0.9

* Circuit
I1 N4 VIP 1u
XM3 N2 VIP VIP VDD sky130_fd_pr__pfet_01v8 l=0.5 w=5
R1 N4 N9 10k
C1 VOP VOM 1p
R2 N7 VNEG 10k
R5 N2 VNEG 10k
R4 N4 N4 10k
XM2 VOP N6 N7 GND sky130_fd_pr__nfet_01v8 l=0.5 w=5
R3 N5 VNEG 10k
XM1 N5 VIM VIP VDD sky130_fd_pr__pfet_01v8 l=0.5 w=5
XM4 VOP VCMFB N4 VDD sky130_fd_pr__pfet_01v8 l=0.5 w=5
R6 VOM VNEG 10k
XM5 VOM N9 N9 VDD sky130_fd_pr__pfet_01v8 l=0.5 w=5

.control
set filetype=ascii

op
let power_dc = abs(i(VVDD)) * 1.8
let vout_dc = v(VOP)
print power_dc vout_dc

ac dec 100 1 10g
let gain_db = db(vm(VOP))
meas ac dc_gain_db FIND gain_db AT=1
meas ac ugbw WHEN gain_db=0 CROSS=1
print dc_gain_db ugbw

quit
.endc

.end
