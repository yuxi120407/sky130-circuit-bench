* Testcase 001186 — Full Analysis (sky130 tt corner)
* SKY130 model header — replaces the ideal level-1 .model cards
* Ships with the demo; the paths point at the local sky130 PDK checkout.
* NOTE: libs.tech/ngspice/all.spice sets ".option scale=1.0u", so every
* instance L/W below is written in microns WITHOUT a "u" suffix.
.param mc_mm_switch=0
.param mc_pr_switch=0
.include /home/idies/workspace/Temporary/xyu1/scratch/skywater-pdk-libs-sky130_fd_pr/models/corners/tt.spice
.include /home/idies/workspace/Temporary/xyu1/scratch/skywater-pdk-libs-sky130_fd_pr/models/r+c/res_typical__cap_typical.spice
.include /home/idies/workspace/Temporary/xyu1/scratch/skywater-pdk-libs-sky130_fd_pr/models/r+c/res_typical__cap_typical__lin.spice
.include /home/idies/workspace/Temporary/xyu1/scratch/skywater-pdk-libs-sky130_fd_pr/models/corners/tt/specialized_cells.spice
.model DIDEAL D   is=1e-14 n=1
.options reltol=1e-3 itl1=500 itl2=100

* Sources
VVDD VDD 0 1.8

* Circuit
I1 VDD GND 1u
I2 N3 GND 1u
I3 N8 GND 1u
R1 VDD N4 10k
XM1 N10 BASEBAND_N N8 GND sky130_fd_pr__nfet_01v8 l=0.5 w=5
R2 VDD N4 10k
XM2 N1 BASEBAND_N VDD GND sky130_fd_pr__nfet_01v8 l=0.5 w=5
XM3 N7 BASEBAND_P VDD GND sky130_fd_pr__nfet_01v8 l=0.5 w=5
XM4 N4 BASEBAND_P N3 GND sky130_fd_pr__nfet_01v8 l=0.5 w=5
XM5 N9 BASEBAND_N N3 GND sky130_fd_pr__nfet_01v8 l=0.5 w=5
XM6 N2 BASEBAND_P N8 GND sky130_fd_pr__nfet_01v8 l=0.5 w=5
XM7 N4 N4 N9 GND sky130_fd_pr__nfet_01v8 l=0.5 w=5
XM8 N4 N4 N2 GND sky130_fd_pr__nfet_01v8 l=0.5 w=5
XM9 N4 N4 N5 GND sky130_fd_pr__nfet_01v8 l=0.5 w=5
XM10 N4 N4 N10 GND sky130_fd_pr__nfet_01v8 l=0.5 w=5
XM11 N4 F2_T N4 GND sky130_fd_pr__nfet_01v8 l=0.5 w=5
XM12 N4 N4 N7 GND sky130_fd_pr__nfet_01v8 l=0.5 w=5
XM13 N4 F3_T N7 GND sky130_fd_pr__nfet_01v8 l=0.5 w=5
XM14 N4 N4 N5 GND sky130_fd_pr__nfet_01v8 l=0.5 w=5
XM15 N4 N4 N9 GND sky130_fd_pr__nfet_01v8 l=0.5 w=5
XM16 N4 F2_T N2 GND sky130_fd_pr__nfet_01v8 l=0.5 w=5
XM17 N4 N4 N1 GND sky130_fd_pr__nfet_01v8 l=0.5 w=5
XM18 N4 F3_T N4 GND sky130_fd_pr__nfet_01v8 l=0.5 w=5

.control
set filetype=ascii

op
let vdd_current = abs(i(VVDD))
let power_dc = vdd_current * 1.8
print power_dc

print all

let vout_dc = v(N4)
print vout_dc
let vout_dc = v(N2)
print vout_dc
quit
.endc

.end
