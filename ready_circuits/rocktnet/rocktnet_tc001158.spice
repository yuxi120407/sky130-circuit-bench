* Testcase 001158 — Full Analysis (sky130 tt corner)
* SKY130 model header — replaces the ideal level-1 .model cards
* Ships with the demo; the paths point at the local sky130 PDK checkout.
* NOTE: libs.tech/ngspice/all.spice sets ".option scale=1.0u", so every
* instance L/W below is written in microns WITHOUT a "u" suffix.
.param mc_mm_switch=0
.param mc_pr_switch=0
.include /home/idies/workspace/Temporary/xyu1/scratch/skywater-pdk-libs-sky130_fd_pr/models/corners/tt.spice
.include /home/idies/workspace/Temporary/xyu1/scratch/skywater-pdk-libs-sky130_fd_pr/models/r+c/res_typical__cap_typical.spice
.include /home/idies/workspace/Temporary/xyu1/scratch/skywater-pdk-libs-sky130_fd_pr/models/r+c/res_typical__cap_typical__lin.spice
.include /home/idies/workspace/Temporary/xyu1/scratch/skywater-pdk-libs-sky130_fd_pr/models/corners/tt/specialized_cells.spice
.model DIDEAL D   is=1e-14 n=1
.options reltol=1e-3 itl1=500 itl2=100

* Sources
VVDD VDD 0 1.8
VVIN_MINUS VIN_MINUS 0 DC 0.9 AC 1 SIN(0.9 0.1 1MEG 0 0)
VVB3 VB3 0 0.54
VVB4 VB4 0 0.9900000000000001
VVIN_PLUS VIN_PLUS 0 DC 0.9 AC 1 SIN(0.9 0.1 1MEG 0 0)
VVB2 VB2 0 0.54
VLABEL_NET_5 LABEL_NET_5 0 0.9
VLABEL_NET_6 LABEL_NET_6 0 0.9

* Circuit
XM1 N8 N2 N12 VDD sky130_fd_pr__pfet_01v8 l=0.5 w=5
XM2 N5 VIN_MINUS N10 GND sky130_fd_pr__nfet_01v8 l=0.5 w=5
XM3 N10 VB3 N15 GND sky130_fd_pr__nfet_01v8 l=0.5 w=5
XM4 VO_MINUS N16 N19 GND sky130_fd_pr__nfet_01v8 l=0.5 w=5
XM5 VO_PLUS N15 N17 GND sky130_fd_pr__nfet_01v8 l=0.5 w=5
XM6 N17 N9 GND GND sky130_fd_pr__nfet_01v8 l=0.5 w=5
XM7 N2 N18 N20 GND sky130_fd_pr__nfet_01v8 l=0.5 w=5
XM8 N20 N7 GND GND sky130_fd_pr__nfet_01v8 l=0.5 w=5
XM9 N2 CM_REF N8 VDD sky130_fd_pr__pfet_01v8 l=0.5 w=5
XM10 N5 N2 N11 VDD sky130_fd_pr__pfet_01v8 l=0.5 w=5
XM11 N19 N9 GND GND sky130_fd_pr__nfet_01v8 l=0.5 w=5
XM12 VO_PLUS VB4 N5 VDD sky130_fd_pr__pfet_01v8 l=0.5 w=5
XM13 N5 VIN_PLUS N10 GND sky130_fd_pr__nfet_01v8 l=0.5 w=5
XM14 N9 VB2 GND GND sky130_fd_pr__nfet_01v8 l=0.5 w=5
XM15 N5 N2 N11 VDD sky130_fd_pr__pfet_01v8 l=0.5 w=5
XM16 N11 VO_PLUS N11 VDD sky130_fd_pr__pfet_01v8 l=0.5 w=5
XMT1 N11 VO_MINUS LABEL_NET_5 VDD sky130_fd_pr__pfet_01v8 l=0.5 w=5
XM18 VO_MINUS VB4 N5 VDD sky130_fd_pr__pfet_01v8 l=0.5 w=5
XMT2 N12 CMFB LABEL_NET_6 VDD sky130_fd_pr__pfet_01v8 l=0.5 w=5

.control
set filetype=ascii

op
let power_dc = abs(i(VVDD)) * 1.8
print power_dc

ac dec 100 1 10g
let vout_mag = vm(N10)
let gain_db = db(vout_mag)
let dc_gain_db = gain_db[0]
print dc_gain_db

if dc_gain_db > 0
    meas ac ugbw WHEN gain_db=0 CROSS=1
    print ugbw
end

quit
.endc

.end
