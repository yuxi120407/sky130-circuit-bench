* Testcase 001034 — Full Analysis (sky130 tt corner)
* SKY130 model header — replaces the ideal level-1 .model cards
* Ships with the demo; the paths point at the local sky130 PDK checkout.
* NOTE: libs.tech/ngspice/all.spice sets ".option scale=1.0u", so every
* instance L/W below is written in microns WITHOUT a "u" suffix.
.param mc_mm_switch=0
.param mc_pr_switch=0
.include /home/idies/workspace/Temporary/xyu1/scratch/skywater-pdk-libs-sky130_fd_pr/models/corners/tt.spice
.include /home/idies/workspace/Temporary/xyu1/scratch/skywater-pdk-libs-sky130_fd_pr/models/r+c/res_typical__cap_typical.spice
.include /home/idies/workspace/Temporary/xyu1/scratch/skywater-pdk-libs-sky130_fd_pr/models/r+c/res_typical__cap_typical__lin.spice
.include /home/idies/workspace/Temporary/xyu1/scratch/skywater-pdk-libs-sky130_fd_pr/models/corners/tt/specialized_cells.spice
.model DIDEAL D   is=1e-14 n=1
.options reltol=1e-3 itl1=500 itl2=100

* Sources
VVDD VDD 0 1.8

* Circuit
I1 VDD N_TAIL_IN 1u
XM5 N_M5_D DIN_P N_TAIL_IN VDD sky130_fd_pr__pfet_01v8 l=0.5 w=5
XM6 N_M6_D DIN_N N_TAIL_IN VDD sky130_fd_pr__pfet_01v8 l=0.5 w=5
XM7 N_M5_D N_M5_D GND GND sky130_fd_pr__nfet_01v8 l=0.5 w=5
XM8 N_M6_D N_M6_D GND GND sky130_fd_pr__nfet_01v8 l=0.5 w=5
XMT N_MT_D N_MT_D VDD VDD sky130_fd_pr__pfet_01v8 l=0.5 w=5
XM3 N_M3_D N_MT_D VDD VDD sky130_fd_pr__pfet_01v8 l=0.5 w=5
XM4 N_M4_D N_MT_D VDD VDD sky130_fd_pr__pfet_01v8 l=0.5 w=5
XM1 N_M3_D VVCO_P N_M1_S GND sky130_fd_pr__nfet_01v8 l=0.5 w=5
XM2 N_M4_D VVCO_N N_M1_S GND sky130_fd_pr__nfet_01v8 l=0.5 w=5
XMB2 N_MT_D N_M6_D GND GND sky130_fd_pr__nfet_01v8 l=0.5 w=5
XMB1 N_M1_S N_M6_D GND GND sky130_fd_pr__nfet_01v8 l=0.5 w=5
CP1 N_M3_D GND 1p
CP2 N_M4_D GND 1p
XM9 N_M9_D N_M9_D VDD VDD sky130_fd_pr__pfet_01v8 l=0.5 w=5
XM10 VOUT_P N_M9_D VDD VDD sky130_fd_pr__pfet_01v8 l=0.5 w=5
XM11 VOUT_N N_M9_D VDD VDD sky130_fd_pr__pfet_01v8 l=0.5 w=5
XM12 VOUT_P N_M4_D N_M12_S GND sky130_fd_pr__nfet_01v8 l=0.5 w=5
XM13 VOUT_N N_M3_D N_M12_S GND sky130_fd_pr__nfet_01v8 l=0.5 w=5
XM14 N_M9_D N_M5_D GND GND sky130_fd_pr__nfet_01v8 l=0.5 w=5
XM15 N_M12_S N_M5_D GND GND sky130_fd_pr__nfet_01v8 l=0.5 w=5
CP3 VOUT_P GND 1p
CP4 VOUT_N GND 1p

.control
set filetype=ascii

op
let vdd_current = abs(i(VVDD))
let power_dc = vdd_current * 1.8
print power_dc

ac dec 100 1 10g
let vout_mag = vm(N_M3_D)
let gain_db = db(vout_mag)
let dc_gain_db = gain_db[0]
print dc_gain_db

if dc_gain_db > 0
    meas ac ugbw WHEN gain_db=0 CROSS=1
end

quit
.endc

.end
