* Testcase 000900 — Full Analysis (sky130 tt corner)
* SKY130 model header — replaces the ideal level-1 .model cards
* Ships with the demo; the paths point at the local sky130 PDK checkout.
* NOTE: libs.tech/ngspice/all.spice sets ".option scale=1.0u", so every
* instance L/W below is written in microns WITHOUT a "u" suffix.
.param mc_mm_switch=0
.param mc_pr_switch=0
.include /home/idies/workspace/Temporary/xyu1/scratch/skywater-pdk-libs-sky130_fd_pr/models/corners/tt.spice
.include /home/idies/workspace/Temporary/xyu1/scratch/skywater-pdk-libs-sky130_fd_pr/models/r+c/res_typical__cap_typical.spice
.include /home/idies/workspace/Temporary/xyu1/scratch/skywater-pdk-libs-sky130_fd_pr/models/r+c/res_typical__cap_typical__lin.spice
.include /home/idies/workspace/Temporary/xyu1/scratch/skywater-pdk-libs-sky130_fd_pr/models/corners/tt/specialized_cells.spice
.model DIDEAL D   is=1e-14 n=1
.options reltol=1e-3 itl1=500 itl2=100

* Sources
VVDD VDD 0 1.8
VVCONTROL_N VCONTROL_N 0 DC 0.9 AC 0.5
VVCONTROL_P VCONTROL_P 0 0.9

* Circuit
I1 E_TAIL GND 1u
XQ1 VEQ_P VFAST_N E_LEFT 0 sky130_fd_pr__npn_05v5_W1p00L1p00
XQ2 E_RIGHT VCONTROL_N E_TAIL 0 sky130_fd_pr__npn_05v5_W1p00L1p00
XQ3 E_LEFT VCONTROL_P E_TAIL 0 sky130_fd_pr__npn_05v5_W1p00L1p00
XQ4 VEQ_N VFAST_P E_LEFT 0 sky130_fd_pr__npn_05v5_W1p00L1p00
XQ5 VEQ_P VSLOW_P E_RIGHT 0 sky130_fd_pr__npn_05v5_W1p00L1p00
XQ6 VEQ_N VSLOW_N E_RIGHT 0 sky130_fd_pr__npn_05v5_W1p00L1p00
R1 VDD VEQ_P 10k
R2 VDD VEQ_N 10k

.control
set filetype=ascii

op
let power_dc = abs(i(VVDD)) * 1.8
print power_dc

ac dec 100 1 10g
let vout_mag = vm(E_RIGHT)
let gain_db = db(vout_mag)
let dc_gain_db = gain_db[0]
print dc_gain_db

if dc_gain_db > 0
    meas ac ugbw WHEN gain_db=0 CROSS=1
    print ugbw
end

quit
.endc

.end
