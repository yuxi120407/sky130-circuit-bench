* Testcase 000950 — Full Analysis (sky130 tt corner)
* SKY130 model header — replaces the ideal level-1 .model cards
* Ships with the demo; the paths point at the local sky130 PDK checkout.
* NOTE: libs.tech/ngspice/all.spice sets ".option scale=1.0u", so every
* instance L/W below is written in microns WITHOUT a "u" suffix.
.param mc_mm_switch=0
.param mc_pr_switch=0
.include /home/idies/workspace/Temporary/xyu1/scratch/skywater-pdk-libs-sky130_fd_pr/models/corners/tt.spice
.include /home/idies/workspace/Temporary/xyu1/scratch/skywater-pdk-libs-sky130_fd_pr/models/r+c/res_typical__cap_typical.spice
.include /home/idies/workspace/Temporary/xyu1/scratch/skywater-pdk-libs-sky130_fd_pr/models/r+c/res_typical__cap_typical__lin.spice
.include /home/idies/workspace/Temporary/xyu1/scratch/skywater-pdk-libs-sky130_fd_pr/models/corners/tt/specialized_cells.spice
.model DIDEAL D   is=1e-14 n=1
.options reltol=1e-3 itl1=500 itl2=100

* Sources
VVDD VDD 0 1.8

* Circuit
XM1 N0 V1N N1 GND sky130_fd_pr__nfet_01v8 l=0.5 w=5
XM2 VON VOP N4 GND sky130_fd_pr__nfet_01v8 l=0.5 w=5
XM3 VOP VON VDD VDD sky130_fd_pr__pfet_01v8 l=0.5 w=5
XM4 VOP VON N0 GND sky130_fd_pr__nfet_01v8 l=0.5 w=5
XM5 N0 CLOCK VDD VDD sky130_fd_pr__pfet_01v8 l=0.5 w=5
XM6 VOP CLOCK VDD VDD sky130_fd_pr__pfet_01v8 l=0.5 w=5
XM7 N1 CLOCK GND GND sky130_fd_pr__nfet_01v8 l=0.5 w=5
XM8 VON CLOCK VDD VDD sky130_fd_pr__pfet_01v8 l=0.5 w=5
XM9 VON VOP VDD VDD sky130_fd_pr__pfet_01v8 l=0.5 w=5
XM10 N4 CLOCK VDD VDD sky130_fd_pr__pfet_01v8 l=0.5 w=5
XM11 N4 V1P N1 GND sky130_fd_pr__nfet_01v8 l=0.5 w=5

.control
set filetype=ascii

op
let power_dc = abs(i(VVDD)) * 1.8
let vout_dc = v(VOP)
print power_dc vout_dc

quit
.endc

.end
