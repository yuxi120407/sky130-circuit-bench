* Testcase 000974 — Full Analysis (sky130 tt corner)
* SKY130 model header — replaces the ideal level-1 .model cards
* Ships with the demo; the paths point at the local sky130 PDK checkout.
* NOTE: libs.tech/ngspice/all.spice sets ".option scale=1.0u", so every
* instance L/W below is written in microns WITHOUT a "u" suffix.
.param mc_mm_switch=0
.param mc_pr_switch=0
.include /home/idies/workspace/Temporary/xyu1/scratch/skywater-pdk-libs-sky130_fd_pr/models/corners/tt.spice
.include /home/idies/workspace/Temporary/xyu1/scratch/skywater-pdk-libs-sky130_fd_pr/models/r+c/res_typical__cap_typical.spice
.include /home/idies/workspace/Temporary/xyu1/scratch/skywater-pdk-libs-sky130_fd_pr/models/r+c/res_typical__cap_typical__lin.spice
.include /home/idies/workspace/Temporary/xyu1/scratch/skywater-pdk-libs-sky130_fd_pr/models/corners/tt/specialized_cells.spice
.model DIDEAL D   is=1e-14 n=1
.options reltol=1e-3 itl1=500 itl2=100

* Sources
VVDD VDD 0 1.8

* Circuit
XML8 N5 N11 VDD VDD sky130_fd_pr__pfet_01v8 l=0.5 w=5
XMR5 N8 N3 GND GND sky130_fd_pr__nfet_01v8 l=0.5 w=5
XMR6 N11 N8 GND GND sky130_fd_pr__nfet_01v8 l=0.5 w=5
XML7 N1 N11 VDD VDD sky130_fd_pr__pfet_01v8 l=0.5 w=5
XMR3 N12 CLKN GND GND sky130_fd_pr__nfet_01v8 l=0.5 w=5
XML3 N14 CLKP GND GND sky130_fd_pr__nfet_01v8 l=0.5 w=5
XML1 N14 CLKP GND GND sky130_fd_pr__nfet_01v8 l=0.5 w=5
XMR8 N11 N5 VDD VDD sky130_fd_pr__pfet_01v8 l=0.5 w=5
XMR2 N12 CLKN N3 VDD sky130_fd_pr__pfet_01v8 l=0.5 w=5
CL VOUT GND 1p
CL1 N5 N14 1p
XML5 N13 N1 GND GND sky130_fd_pr__nfet_01v8 l=0.5 w=5
CR2 N3 N8 1p
XM11 N8 CLKN N11 VDD sky130_fd_pr__pfet_01v8 l=0.5 w=5
XML2 N14 CLKP N1 VDD sky130_fd_pr__pfet_01v8 l=0.5 w=5
CR1 N11 N12 1p
CL2 N1 N13 1p
XMR4 N8 N3 N11 VDD sky130_fd_pr__pfet_01v8 l=0.5 w=5
XML4 N13 N1 N5 VDD sky130_fd_pr__pfet_01v8 l=0.5 w=5
XML6 N5 N13 GND GND sky130_fd_pr__nfet_01v8 l=0.5 w=5
XML9 VOUT N11 N5 N5 sky130_fd_pr__pfet_01v8 l=0.5 w=5
XMR7 N3 N5 VDD VDD sky130_fd_pr__pfet_01v8 l=0.5 w=5
XMR9 VOUT N5 N11 N11 sky130_fd_pr__pfet_01v8 l=0.5 w=5

.control
set filetype=ascii

op
let vdd_current = abs(i(VVDD))
let power_dc = vdd_current * 1.8
print power_dc

ac dec 100 1 10g
let vout_mag = vm(VOUT)
let gain_db = db(vout_mag)
let dc_gain_db = gain_db[0]
print dc_gain_db

if dc_gain_db > 0
    meas ac ugbw WHEN gain_db=0 CROSS=1
end

quit
.endc

.end
