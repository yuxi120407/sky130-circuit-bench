* Testcase 000370 — Full Analysis (sky130 tt corner)
* SKY130 model header — replaces the ideal level-1 .model cards
* Ships with the demo; the paths point at the local sky130 PDK checkout.
* NOTE: libs.tech/ngspice/all.spice sets ".option scale=1.0u", so every
* instance L/W below is written in microns WITHOUT a "u" suffix.
.param mc_mm_switch=0
.param mc_pr_switch=0
.include /home/idies/workspace/Temporary/xyu1/scratch/skywater-pdk-libs-sky130_fd_pr/models/corners/tt.spice
.include /home/idies/workspace/Temporary/xyu1/scratch/skywater-pdk-libs-sky130_fd_pr/models/r+c/res_typical__cap_typical.spice
.include /home/idies/workspace/Temporary/xyu1/scratch/skywater-pdk-libs-sky130_fd_pr/models/r+c/res_typical__cap_typical__lin.spice
.include /home/idies/workspace/Temporary/xyu1/scratch/skywater-pdk-libs-sky130_fd_pr/models/corners/tt/specialized_cells.spice
.model DIDEAL D   is=1e-14 n=1
.options reltol=1e-3 itl1=500 itl2=100

* Sources
VVDD VDD 0 1.8
VVIN_MINUS VIN_MINUS 0 DC 0.9 AC 1 SIN(0.9 0.1 1MEG 0 0)
VLABEL_NET_1 LABEL_NET_1 0 0.9
VVIN_PLUS VIN_PLUS 0 DC 0.9 AC 1 SIN(0.9 0.1 1MEG 0 0)
VVCONTROL VCONTROL 0 0.9

* Circuit
XM7 VOUT_PLUS N4 GND GND sky130_fd_pr__nfet_01v8 l=0.5 w=5
IQBOOST VOUT_PLUS N4 1u
XM5 VOUT_MINUS VOUT_PLUS VOUT_PLUS VOUT_PLUS sky130_fd_pr__nfet_01v8 l=0.5 w=5
XM2 VOUT_PLUS VIN_MINUS N6 N6 sky130_fd_pr__nfet_01v8 l=0.5 w=5
IBIAS LABEL_NET_1 N0 1u
XM1 VOUT_MINUS VIN_PLUS N2 N2 sky130_fd_pr__nfet_01v8 l=0.5 w=5
XM4 N0 N0 GND GND sky130_fd_pr__nfet_01v8 l=0.5 w=5
C1 VOUT_MINUS VCONTROL 1p
XM3 N3 N0 GND GND sky130_fd_pr__nfet_01v8 l=0.5 w=5
L1 VDD VOUT_PLUS 10n
XM8 N4 N4 GND GND sky130_fd_pr__nfet_01v8 l=0.5 w=5
RDEG1 N2 N3 10k
L2 VDD VOUT_MINUS 10n
XM6 VOUT_PLUS VOUT_MINUS VOUT_PLUS VOUT_PLUS sky130_fd_pr__nfet_01v8 l=0.5 w=5
RDEG2 N3 N6 10k
C2 VOUT_PLUS VCONTROL 1p

.control
set filetype=ascii

op
let vdd_current = abs(i(VVDD))
let power_dc = vdd_current * 1.8
print power_dc

print all

quit
.endc

.end
