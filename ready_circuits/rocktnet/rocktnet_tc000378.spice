* Testcase 000378 — Full Analysis (sky130 tt corner)
* SKY130 model header — replaces the ideal level-1 .model cards
* Ships with the demo; the paths point at the local sky130 PDK checkout.
* NOTE: libs.tech/ngspice/all.spice sets ".option scale=1.0u", so every
* instance L/W below is written in microns WITHOUT a "u" suffix.
.param mc_mm_switch=0
.param mc_pr_switch=0
.include /home/idies/workspace/Temporary/xyu1/scratch/skywater-pdk-libs-sky130_fd_pr/models/corners/tt.spice
.include /home/idies/workspace/Temporary/xyu1/scratch/skywater-pdk-libs-sky130_fd_pr/models/r+c/res_typical__cap_typical.spice
.include /home/idies/workspace/Temporary/xyu1/scratch/skywater-pdk-libs-sky130_fd_pr/models/r+c/res_typical__cap_typical__lin.spice
.include /home/idies/workspace/Temporary/xyu1/scratch/skywater-pdk-libs-sky130_fd_pr/models/corners/tt/specialized_cells.spice
.model DIDEAL D   is=1e-14 n=1
.options reltol=1e-3 itl1=500 itl2=100

* Sources
VVDD VDD 0 1.8
VVREF VREF 0 0.9

* Circuit
XM9 VREF N0 VDD VDD sky130_fd_pr__pfet_01v8 l=0.5 w=5
XM4 N1 V3 N6 N6 sky130_fd_pr__nfet_01v8 l=0.5 w=5
XM7 N1 N1 VDD VDD sky130_fd_pr__pfet_01v8 l=0.5 w=5
XM6 N0 N1 VDD VDD sky130_fd_pr__pfet_01v8 l=0.5 w=5
R3 V3 VREF 10k
XM3 N0 V2 N6 N6 sky130_fd_pr__nfet_01v8 l=0.5 w=5
R4 V3 GND 10k
R2 V1 GND 10k
R1 V1 V2 10k
XM5 VDD N5 V2 V2 sky130_fd_pr__nfet_01v8 l=0.5 w=5
XM1 N5 N5 VDD N5 sky130_fd_pr__pfet_01v8 l=0.5 w=5
XM8 N6 GND GND GND sky130_fd_pr__nfet_01v8 l=0.5 w=5

.control
set filetype=ascii

op
let vdd_current = abs(i(VVDD))
let power_dc = vdd_current * 1.8
let vout_dc = v(V3)
print power_dc vout_dc

quit
.endc

.end
