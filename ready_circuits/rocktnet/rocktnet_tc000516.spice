* Testcase 000516 — Full Analysis (sky130 tt corner)
* SKY130 model header — replaces the ideal level-1 .model cards
* Ships with the demo; the paths point at the local sky130 PDK checkout.
* NOTE: libs.tech/ngspice/all.spice sets ".option scale=1.0u", so every
* instance L/W below is written in microns WITHOUT a "u" suffix.
.param mc_mm_switch=0
.param mc_pr_switch=0
.include /home/idies/workspace/Temporary/xyu1/scratch/skywater-pdk-libs-sky130_fd_pr/models/corners/tt.spice
.include /home/idies/workspace/Temporary/xyu1/scratch/skywater-pdk-libs-sky130_fd_pr/models/r+c/res_typical__cap_typical.spice
.include /home/idies/workspace/Temporary/xyu1/scratch/skywater-pdk-libs-sky130_fd_pr/models/r+c/res_typical__cap_typical__lin.spice
.include /home/idies/workspace/Temporary/xyu1/scratch/skywater-pdk-libs-sky130_fd_pr/models/corners/tt/specialized_cells.spice
.model DIDEAL D   is=1e-14 n=1
.options reltol=1e-3 itl1=500 itl2=100

* Sources
VIN IN 0 DC 0.9 AC 1 SIN(0.9 0.1 1MEG 0 0)
VIN* IN* 0 DC 0.9 AC 1 SIN(0.9 0.1 1MEG 0 0)

* Circuit
R4 GND N1 10k
R1 GND N2 10k
R2 GND N3 10k
R3 GND N4 10k
XQ7 N1 IN N5 0 sky130_fd_pr__npn_05v5_W1p00L1p00
XQ11 N2 IN* N5 0 sky130_fd_pr__npn_05v5_W1p00L1p00
XQ1 GND N1 N6 0 sky130_fd_pr__npn_05v5_W1p00L1p00
XQ9 GND N2 N7 0 sky130_fd_pr__npn_05v5_W1p00L1p00
XQ5 N3 N6 N8 0 sky130_fd_pr__npn_05v5_W1p00L1p00
XQ10 N4 N7 N8 0 sky130_fd_pr__npn_05v5_W1p00L1p00
XQ3 N3 OUT* N10 0 sky130_fd_pr__npn_05v5_W1p00L1p00
XQ2 N4 OUT N10 0 sky130_fd_pr__npn_05v5_W1p00L1p00
XQ6 N8 CLK N11 0 sky130_fd_pr__npn_05v5_W1p00L1p00
XQ12 N10 CLK* N11 0 sky130_fd_pr__npn_05v5_W1p00L1p00
XQ4 GND N3 OUT 0 sky130_fd_pr__npn_05v5_W1p00L1p00
XQ8 GND N4 OUT* 0 sky130_fd_pr__npn_05v5_W1p00L1p00
I1 N5 VEE 1u
I2 N6 VEE 1u
I3 N7 VEE 1u
I5 N11 VEE 1u
I6 OUT VEE 1u
I4 OUT* VEE 1u

.control
set filetype=ascii

op
let vdd_current = abs(i(VVDD))
let power_dc = vdd_current * 1.8
print power_dc

ac dec 100 1 10g
let vout_mag = vm(OUT)
let gain_db = db(vout_mag)
let dc_gain_db = gain_db[0]
print dc_gain_db

if dc_gain_db > 0
    meas ac ugbw WHEN gain_db=0 CROSS=1
end

quit
.endc

.end
