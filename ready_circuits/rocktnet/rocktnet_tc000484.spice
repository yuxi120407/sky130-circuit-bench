* Testcase 000484 — Full Analysis (sky130 tt corner)
* SKY130 model header — replaces the ideal level-1 .model cards
* Ships with the demo; the paths point at the local sky130 PDK checkout.
* NOTE: libs.tech/ngspice/all.spice sets ".option scale=1.0u", so every
* instance L/W below is written in microns WITHOUT a "u" suffix.
.param mc_mm_switch=0
.param mc_pr_switch=0
.include /home/idies/workspace/Temporary/xyu1/scratch/skywater-pdk-libs-sky130_fd_pr/models/corners/tt.spice
.include /home/idies/workspace/Temporary/xyu1/scratch/skywater-pdk-libs-sky130_fd_pr/models/r+c/res_typical__cap_typical.spice
.include /home/idies/workspace/Temporary/xyu1/scratch/skywater-pdk-libs-sky130_fd_pr/models/r+c/res_typical__cap_typical__lin.spice
.include /home/idies/workspace/Temporary/xyu1/scratch/skywater-pdk-libs-sky130_fd_pr/models/corners/tt/specialized_cells.spice
.model DIDEAL D   is=1e-14 n=1
.options reltol=1e-3 itl1=500 itl2=100

* Sources
VVDD VDD 0 1.8
VVSS VSS 0 0
VINP INP 0 DC 0.9 AC 1 SIN(0.9 0.1 1MEG 0 0)
VVREFN VREFN 0 0.9
VVREFP VREFP 0 0.9
VINN INN 0 DC 0.9 AC 1 SIN(0.9 0.1 1MEG 0 0)

* Circuit
XM1 N1 LATCH VSS VSS sky130_fd_pr__nfet_01v8 l=0.5 w=5
XM2 N2 INP N1 VSS sky130_fd_pr__nfet_01v8 l=0.5 w=5
XM3 N2 VREFN N1 VSS sky130_fd_pr__nfet_01v8 l=0.5 w=5
XM4 N3 VREFP N1 VSS sky130_fd_pr__nfet_01v8 l=0.5 w=5
XM5 N3 INN N1 VSS sky130_fd_pr__nfet_01v8 l=0.5 w=5
XM6 VOUT_MINUS VOUT_PLUS N2 VSS sky130_fd_pr__nfet_01v8 l=0.5 w=5
XM7 VOUT_PLUS VOUT_MINUS N3 VSS sky130_fd_pr__nfet_01v8 l=0.5 w=5
XM8 N2 LATCH VDD VDD sky130_fd_pr__pfet_01v8 l=0.5 w=5
XM9 VOUT_MINUS LATCH VDD VDD sky130_fd_pr__pfet_01v8 l=0.5 w=5
XM10 VOUT_MINUS VOUT_PLUS VDD VDD sky130_fd_pr__pfet_01v8 l=0.5 w=5
XM11 VOUT_PLUS VOUT_MINUS VDD VDD sky130_fd_pr__pfet_01v8 l=0.5 w=5
XM12 VOUT_PLUS LATCH VDD VDD sky130_fd_pr__pfet_01v8 l=0.5 w=5
XM13 N3 LATCH VDD VDD sky130_fd_pr__pfet_01v8 l=0.5 w=5

.control
set filetype=ascii

op
let vdd_current = abs(i(VVDD))
let power_dc = vdd_current * 1.8
print power_dc

print all

quit
.endc

.end
