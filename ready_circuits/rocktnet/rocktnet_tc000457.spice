* Testcase 000457 — Full Analysis (sky130 tt corner)
* SKY130 model header — replaces the ideal level-1 .model cards
* Ships with the demo; the paths point at the local sky130 PDK checkout.
* NOTE: libs.tech/ngspice/all.spice sets ".option scale=1.0u", so every
* instance L/W below is written in microns WITHOUT a "u" suffix.
.param mc_mm_switch=0
.param mc_pr_switch=0
.include /home/idies/workspace/Temporary/xyu1/scratch/skywater-pdk-libs-sky130_fd_pr/models/corners/tt.spice
.include /home/idies/workspace/Temporary/xyu1/scratch/skywater-pdk-libs-sky130_fd_pr/models/r+c/res_typical__cap_typical.spice
.include /home/idies/workspace/Temporary/xyu1/scratch/skywater-pdk-libs-sky130_fd_pr/models/r+c/res_typical__cap_typical__lin.spice
.include /home/idies/workspace/Temporary/xyu1/scratch/skywater-pdk-libs-sky130_fd_pr/models/corners/tt/specialized_cells.spice
.model DIDEAL D   is=1e-14 n=1
.options reltol=1e-3 itl1=500 itl2=100

* Sources
VVDD VDD 0 1.8

* Circuit
XMP1 N_L1 CLKBAR VDD VDD sky130_fd_pr__pfet_01v8 l=0.5 w=5
XMP2 N_L2 CLKBAR VDD VDD sky130_fd_pr__pfet_01v8 l=0.5 w=5
XMP3 N_R1 CLK VDD VDD sky130_fd_pr__pfet_01v8 l=0.5 w=5
XMP4 N_R2 CLK VDD VDD sky130_fd_pr__pfet_01v8 l=0.5 w=5
XMN1 N_L1 N_L2 N_TL1 GND sky130_fd_pr__nfet_01v8 l=0.5 w=5
XMN2 N_L2 N_L1 N_TL1 GND sky130_fd_pr__nfet_01v8 l=0.5 w=5
XMN3 N_TL1 CLKBAR GND GND sky130_fd_pr__nfet_01v8 l=0.5 w=5
XMN4 N_L1 N_R1 N_TL2 GND sky130_fd_pr__nfet_01v8 l=0.5 w=5
XMN5 N_L2 N_R2 N_TL2 GND sky130_fd_pr__nfet_01v8 l=0.5 w=5
XMN6 N_TL2 CLK GND GND sky130_fd_pr__nfet_01v8 l=0.5 w=5
XMN7 N_R1 N_R2 N_TR1 GND sky130_fd_pr__nfet_01v8 l=0.5 w=5
XMN8 N_R2 N_R1 N_TR1 GND sky130_fd_pr__nfet_01v8 l=0.5 w=5
XMN9 N_TR1 CLK GND GND sky130_fd_pr__nfet_01v8 l=0.5 w=5
XMN10 N_R1 N_L2 N_TR2 GND sky130_fd_pr__nfet_01v8 l=0.5 w=5
XMN11 N_R2 N_L1 N_TR2 GND sky130_fd_pr__nfet_01v8 l=0.5 w=5
XMN12 N_TR2 CLKBAR GND GND sky130_fd_pr__nfet_01v8 l=0.5 w=5

.control
set filetype=ascii

op
let vdd_current = abs(i(VVDD))
let power_dc = vdd_current * 1.8
print power_dc

print all

let vout_dc = v(N_R2)
print vout_dc
let vout_dc = v(N_L2)
print vout_dc
quit
.endc

.end
