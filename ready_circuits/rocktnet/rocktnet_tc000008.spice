* Testcase 000008 — Full Analysis (sky130 tt corner)
* SKY130 model header — replaces the ideal level-1 .model cards
* Ships with the demo; the paths point at the local sky130 PDK checkout.
* NOTE: libs.tech/ngspice/all.spice sets ".option scale=1.0u", so every
* instance L/W below is written in microns WITHOUT a "u" suffix.
.param mc_mm_switch=0
.param mc_pr_switch=0
.include /home/idies/workspace/Temporary/xyu1/scratch/skywater-pdk-libs-sky130_fd_pr/models/corners/tt.spice
.include /home/idies/workspace/Temporary/xyu1/scratch/skywater-pdk-libs-sky130_fd_pr/models/r+c/res_typical__cap_typical.spice
.include /home/idies/workspace/Temporary/xyu1/scratch/skywater-pdk-libs-sky130_fd_pr/models/r+c/res_typical__cap_typical__lin.spice
.include /home/idies/workspace/Temporary/xyu1/scratch/skywater-pdk-libs-sky130_fd_pr/models/corners/tt/specialized_cells.spice
.model DIDEAL D   is=1e-14 n=1
.options reltol=1e-3 itl1=500 itl2=100

* Sources
VVDD VDD 0 1.8
VLABEL_NET_0 LABEL_NET_0 0 0.9
VLABEL_NET_1 LABEL_NET_1 0 0.9

* Circuit
XM1 N9 N8 N10 VDD sky130_fd_pr__pfet_01v8 l=0.5 w=5
XM2 N8 N8 N10 VDD sky130_fd_pr__pfet_01v8 l=0.5 w=5
XM3 N4 N4 N10 VDD sky130_fd_pr__pfet_01v8 l=0.5 w=5
XM4 N1 N4 N10 VDD sky130_fd_pr__pfet_01v8 l=0.5 w=5
I1 N7 GND 1u
I2 N5 GND 1u
I3 N0 GND 1u
R1 N6 GND 10k
R2 GND GND 10k
XQ1 N3 LABEL_NET_0 N7 0 sky130_fd_pr__npn_05v5_W1p00L1p00
XQ2 N1 N1 N6 0 sky130_fd_pr__npn_05v5_W1p00L1p00
R3 N5 N7 10k
XQ3 N9 N1 GND 0 sky130_fd_pr__npn_05v5_W1p00L1p00
XQ4 N2 LABEL_NET_1 N5 0 sky130_fd_pr__npn_05v5_W1p00L1p00
XQ5 N4 N2 N0 0 sky130_fd_pr__npn_05v5_W1p00L1p00
XQ6 N8 N3 N0 0 sky130_fd_pr__npn_05v5_W1p00L1p00
XQ7 N10 N10 N2 0 sky130_fd_pr__npn_05v5_W1p00L1p00
XQ8 N10 N10 N3 0 sky130_fd_pr__npn_05v5_W1p00L1p00

.control
set filetype=ascii

op
let vdd_current = abs(i(VVDD))
let power_dc = vdd_current * 1.8
let vout_dc = v(N6)
print power_dc vout_dc

quit
.endc

.end
