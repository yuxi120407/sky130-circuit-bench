* Testcase 001093 — Full Analysis (sky130 tt corner)
* SKY130 model header — replaces the ideal level-1 .model cards
* Ships with the demo; the paths point at the local sky130 PDK checkout.
* NOTE: libs.tech/ngspice/all.spice sets ".option scale=1.0u", so every
* instance L/W below is written in microns WITHOUT a "u" suffix.
.param mc_mm_switch=0
.param mc_pr_switch=0
.include /home/idies/workspace/Temporary/xyu1/scratch/skywater-pdk-libs-sky130_fd_pr/models/corners/tt.spice
.include /home/idies/workspace/Temporary/xyu1/scratch/skywater-pdk-libs-sky130_fd_pr/models/r+c/res_typical__cap_typical.spice
.include /home/idies/workspace/Temporary/xyu1/scratch/skywater-pdk-libs-sky130_fd_pr/models/r+c/res_typical__cap_typical__lin.spice
.include /home/idies/workspace/Temporary/xyu1/scratch/skywater-pdk-libs-sky130_fd_pr/models/corners/tt/specialized_cells.spice
.model DIDEAL D   is=1e-14 n=1
.options reltol=1e-3 itl1=500 itl2=100

* Sources
VVDD VDD 0 1.8
VLABEL_NET_0 LABEL_NET_0 0 DC 0.9 AC 0.5
VLABEL_NET_1 LABEL_NET_1 0 DC 0.9 AC -0.5

* Circuit
I1 N8 GND 1u
XM1 N12 N4 VDD VDD sky130_fd_pr__pfet_01v8 l=0.5 w=5
I2 N4 GND 1u
I3 N1 GND 1u
I4 N10 GND 1u
XM2 N0 N1 VDD VDD sky130_fd_pr__pfet_01v8 l=0.5 w=5
XM3 N6 LABEL_NET_0 N7 VDD sky130_fd_pr__pfet_01v8 l=0.5 w=5
XM4 VDD VDD N3 VDD sky130_fd_pr__pfet_01v8 l=0.5 w=5
XM5 N7 N7 GND GND sky130_fd_pr__nfet_01v8 l=0.5 w=5
XM6 N9 N7 GND GND sky130_fd_pr__nfet_01v8 l=0.5 w=5
XM7 N11 N11 GND GND sky130_fd_pr__nfet_01v8 l=0.5 w=5
XM8 N4 VDD N12 VDD sky130_fd_pr__pfet_01v8 l=0.5 w=5
XM9 VDD N11 GND GND sky130_fd_pr__nfet_01v8 l=0.5 w=5
XM10 N6 N10 VDD VDD sky130_fd_pr__pfet_01v8 l=0.5 w=5
XM11 N9 N9 VDD VDD sky130_fd_pr__pfet_01v8 l=0.5 w=5
XM12 N1 N9 N0 VDD sky130_fd_pr__pfet_01v8 l=0.5 w=5
XM13 N7 LABEL_NET_1 N0 VDD sky130_fd_pr__pfet_01v8 l=0.5 w=5
XM14 N2 VDD N5 VDD sky130_fd_pr__pfet_01v8 l=0.5 w=5
XM15 N11 N9 N3 VDD sky130_fd_pr__pfet_01v8 l=0.5 w=5
XM16 N10 N10 N6 VDD sky130_fd_pr__pfet_01v8 l=0.5 w=5
XM17 N5 N2 VDD VDD sky130_fd_pr__pfet_01v8 l=0.5 w=5
XM18 N8 N2 N5 VDD sky130_fd_pr__pfet_01v8 l=0.5 w=5
C1 N9 GND 1p
XM19 N9 VDD N0 VDD sky130_fd_pr__pfet_01v8 l=0.5 w=5
C2 VDD GND 1p

.control
set filetype=ascii

op
let vdd_current = abs(i(VVDD))
let power_dc = vdd_current * 1.8
print power_dc

ac dec 100 1 10g
let vout_mag = vm(N9)
let gain_db = db(vout_mag)
let dc_gain_db = gain_db[0]
print dc_gain_db

if dc_gain_db > 0
    meas ac ugbw WHEN gain_db=0 CROSS=1
end

quit
.endc

.end
