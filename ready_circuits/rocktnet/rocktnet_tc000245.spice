* Testcase 000245 — Full Analysis (sky130 tt corner)
* SKY130 model header — replaces the ideal level-1 .model cards
* Ships with the demo; the paths point at the local sky130 PDK checkout.
* NOTE: libs.tech/ngspice/all.spice sets ".option scale=1.0u", so every
* instance L/W below is written in microns WITHOUT a "u" suffix.
.param mc_mm_switch=0
.param mc_pr_switch=0
.include /home/idies/workspace/Temporary/xyu1/scratch/skywater-pdk-libs-sky130_fd_pr/models/corners/tt.spice
.include /home/idies/workspace/Temporary/xyu1/scratch/skywater-pdk-libs-sky130_fd_pr/models/r+c/res_typical__cap_typical.spice
.include /home/idies/workspace/Temporary/xyu1/scratch/skywater-pdk-libs-sky130_fd_pr/models/r+c/res_typical__cap_typical__lin.spice
.include /home/idies/workspace/Temporary/xyu1/scratch/skywater-pdk-libs-sky130_fd_pr/models/corners/tt/specialized_cells.spice
.model DIDEAL D   is=1e-14 n=1
.options reltol=1e-3 itl1=500 itl2=100

* Sources
VVINp VINp 0 DC 0.9 AC 1 SIN(0.9 0.1 1MEG 0 0)
VVINn VINn 0 DC 0.9 AC 1 SIN(0.9 0.1 1MEG 0 0)

* Circuit
I1 NET_E1 GND 1u
I2 NET_E2 GND 1u
L1 VCC NET_C2 10n
L2 VCC NET_C1 10n
RC NET_C1 NET_C2 10k
RE NET_E1 NET_E2 10k
XQ1 NET_C1 NET_B1 NET_E1 0 sky130_fd_pr__npn_05v5_W1p00L1p00
XQ2 NET_C2 NET_B2 NET_E2 0 sky130_fd_pr__npn_05v5_W1p00L1p00
C1 NET_C2 VOUTp 1p
C2 NET_C1 VOUTn 1p

.control
set filetype=ascii

op
let vdd_current = abs(i(VVDD))
let power_dc = vdd_current * 1.8
print power_dc

print all

quit
.endc

.end
