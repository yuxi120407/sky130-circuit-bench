* Testcase 000778 — Full Analysis (sky130 tt corner)
* SKY130 model header — replaces the ideal level-1 .model cards
* Ships with the demo; the paths point at the local sky130 PDK checkout.
* NOTE: libs.tech/ngspice/all.spice sets ".option scale=1.0u", so every
* instance L/W below is written in microns WITHOUT a "u" suffix.
.param mc_mm_switch=0
.param mc_pr_switch=0
.include /home/idies/workspace/Temporary/xyu1/scratch/skywater-pdk-libs-sky130_fd_pr/models/corners/tt.spice
.include /home/idies/workspace/Temporary/xyu1/scratch/skywater-pdk-libs-sky130_fd_pr/models/r+c/res_typical__cap_typical.spice
.include /home/idies/workspace/Temporary/xyu1/scratch/skywater-pdk-libs-sky130_fd_pr/models/r+c/res_typical__cap_typical__lin.spice
.include /home/idies/workspace/Temporary/xyu1/scratch/skywater-pdk-libs-sky130_fd_pr/models/corners/tt/specialized_cells.spice
.model DIDEAL D   is=1e-14 n=1
.options reltol=1e-3 itl1=500 itl2=100

* Sources
VVDD VDD 0 1.8
VVCLK_I VCLK_I 0 0.0
VVCLK_Q VCLK_Q 0 0.0

* Circuit
I2 N0 GND 1u
R1 VDD VOUT 10k
XM1 VOUT N4 VOUT GND sky130_fd_pr__nfet_01v8 l=0.5 w=5
XM2 VOUT VCLK_I VCLK_I GND sky130_fd_pr__nfet_01v8 l=0.5 w=5
XM3 VOUT VCLK_Q N1 GND sky130_fd_pr__nfet_01v8 l=0.5 w=5
XM4 VOUT VCLK_I N0 GND sky130_fd_pr__nfet_01v8 l=0.5 w=5
XM5 VOUT VCLK_I VCLK_I GND sky130_fd_pr__nfet_01v8 l=0.5 w=5
I3 N1 GND 1u
I1 VCLK_I GND 1u
XM6 VOUT VCLK_Q VCLK_Q GND sky130_fd_pr__nfet_01v8 l=0.5 w=5
XM7 VOUT N4 VCLK_Q GND sky130_fd_pr__nfet_01v8 l=0.5 w=5
R2 VDD VOUT 10k
XM8 VOUT VCLK_I N0 GND sky130_fd_pr__nfet_01v8 l=0.5 w=5
I4 VCLK_Q GND 1u

.control
set filetype=ascii

op
let vdd_current = abs(i(VVDD))
let power_dc = vdd_current * 1.8
let vout_dc = v(VOUT)
print power_dc vout_dc

quit
.endc

.end
