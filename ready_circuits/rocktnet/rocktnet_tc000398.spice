* Testcase 000398 — Full Analysis (sky130 tt corner)
* SKY130 model header — replaces the ideal level-1 .model cards
* Ships with the demo; the paths point at the local sky130 PDK checkout.
* NOTE: libs.tech/ngspice/all.spice sets ".option scale=1.0u", so every
* instance L/W below is written in microns WITHOUT a "u" suffix.
.param mc_mm_switch=0
.param mc_pr_switch=0
.include /home/idies/workspace/Temporary/xyu1/scratch/skywater-pdk-libs-sky130_fd_pr/models/corners/tt.spice
.include /home/idies/workspace/Temporary/xyu1/scratch/skywater-pdk-libs-sky130_fd_pr/models/r+c/res_typical__cap_typical.spice
.include /home/idies/workspace/Temporary/xyu1/scratch/skywater-pdk-libs-sky130_fd_pr/models/r+c/res_typical__cap_typical__lin.spice
.include /home/idies/workspace/Temporary/xyu1/scratch/skywater-pdk-libs-sky130_fd_pr/models/corners/tt/specialized_cells.spice
.model DIDEAL D   is=1e-14 n=1
.options reltol=1e-3 itl1=500 itl2=100

* Sources
VIN_PLUS IN_PLUS 0 DC 0.9 AC 1 SIN(0.9 0.1 1MEG 0 0)
VIN_MINUS IN_MINUS 0 DC 0.9 AC 1 SIN(0.9 0.1 1MEG 0 0)

* Circuit
XM1 N3 N6 N1 GND sky130_fd_pr__nfet_01v8 l=0.5 w=5
C1 N0 OUT_MINUS 1p
XM2 N10 CONTROL N1 GND sky130_fd_pr__nfet_01v8 l=0.5 w=5
C2 N1 N4 1p
R1 N1 OUT_MINUS 10k
R2 N0 N1 10k
R3 IN_PLUS N10 10k
R4 N4 N5 10k
C3 N5 OUT_PLUS 1p
R5 N4 IN_MINUS 10k
XM3 N4 CONTROL IN_MINUS GND sky130_fd_pr__nfet_01v8 l=0.5 w=5
R6 N3 IN_PLUS 10k
R7 N4 OUT_PLUS 10k

.control
set filetype=ascii

op
let power_dc = abs(i(VIN_PLUS)) * 1.8
print power_dc
let dc_voltage = v(N0)
print dc_voltage

quit
.endc

.end
