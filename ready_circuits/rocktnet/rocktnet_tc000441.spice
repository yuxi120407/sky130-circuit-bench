* Testcase 000441 — Full Analysis (sky130 tt corner)
* SKY130 model header — replaces the ideal level-1 .model cards
* Ships with the demo; the paths point at the local sky130 PDK checkout.
* NOTE: libs.tech/ngspice/all.spice sets ".option scale=1.0u", so every
* instance L/W below is written in microns WITHOUT a "u" suffix.
.param mc_mm_switch=0
.param mc_pr_switch=0
.include /home/idies/workspace/Temporary/xyu1/scratch/skywater-pdk-libs-sky130_fd_pr/models/corners/tt.spice
.include /home/idies/workspace/Temporary/xyu1/scratch/skywater-pdk-libs-sky130_fd_pr/models/r+c/res_typical__cap_typical.spice
.include /home/idies/workspace/Temporary/xyu1/scratch/skywater-pdk-libs-sky130_fd_pr/models/r+c/res_typical__cap_typical__lin.spice
.include /home/idies/workspace/Temporary/xyu1/scratch/skywater-pdk-libs-sky130_fd_pr/models/corners/tt/specialized_cells.spice
.model DIDEAL D   is=1e-14 n=1
.options reltol=1e-3 itl1=500 itl2=100

* Sources
VIN_P IN_P 0 DC 0.9 AC 1 SIN(0.9 0.1 1MEG 0 0)
VIN_N IN_N 0 DC 0.9 AC 1 SIN(0.9 0.1 1MEG 0 0)

* Circuit
R16 GND N1 10k
R8 GND N2 10k
R3 GND N6 10k
R1 GND N7 10k
R10 GND N13 10k
R2 GND N14 10k
R11 N18 VEE 10k
R13 N19 VEE 10k
R5 N20 VEE 10k
R4 N21 VEE 10k
R9 N22 VEE 10k
R12 N23 VEE 10k
R7 N24 VEE 10k
R6 N25 VEE 10k
R15 N26 VEE 10k
XQ14 N1 IN_P N3 0 sky130_fd_pr__npn_05v5_W1p00L1p00
XQ25 N2 IN_N N3 0 sky130_fd_pr__npn_05v5_W1p00L1p00
XQ6 N3 V_R N18 0 sky130_fd_pr__npn_05v5_W1p00L1p00
XQ23 GND N1 N4 0 sky130_fd_pr__npn_05v5_W1p00L1p00
XQ2 GND N2 N5 0 sky130_fd_pr__npn_05v5_W1p00L1p00
XQ9 N4 V_R N19 0 sky130_fd_pr__npn_05v5_W1p00L1p00
XQ21 N5 V_R N20 0 sky130_fd_pr__npn_05v5_W1p00L1p00
XQ28 N10 CLK_P N12 0 sky130_fd_pr__npn_05v5_W1p00L1p00
XQ16 N11 CLK_N N12 0 sky130_fd_pr__npn_05v5_W1p00L1p00
XQ13 N12 V_R N21 0 sky130_fd_pr__npn_05v5_W1p00L1p00
XQ24 N6 N4 N10 0 sky130_fd_pr__npn_05v5_W1p00L1p00
XQ30 N7 N5 N10 0 sky130_fd_pr__npn_05v5_W1p00L1p00
XQ10 N6 N9 N11 0 sky130_fd_pr__npn_05v5_W1p00L1p00
XQ8 N7 N8 N11 0 sky130_fd_pr__npn_05v5_W1p00L1p00
XQ12 GND N6 N8 0 sky130_fd_pr__npn_05v5_W1p00L1p00
XQ4 GND N7 N9 0 sky130_fd_pr__npn_05v5_W1p00L1p00
XQ5 N8 V_R N22 0 sky130_fd_pr__npn_05v5_W1p00L1p00
XQ1 N9 V_R N23 0 sky130_fd_pr__npn_05v5_W1p00L1p00
XQ22 N15 CLK_N N17 0 sky130_fd_pr__npn_05v5_W1p00L1p00
XQ27 N16 CLK_P N17 0 sky130_fd_pr__npn_05v5_W1p00L1p00
XQ15 N17 V_R N24 0 sky130_fd_pr__npn_05v5_W1p00L1p00
XQ18 N13 N8 N15 0 sky130_fd_pr__npn_05v5_W1p00L1p00
XQ29 N14 N9 N15 0 sky130_fd_pr__npn_05v5_W1p00L1p00
XQ3 N13 Q_P N16 0 sky130_fd_pr__npn_05v5_W1p00L1p00
XQ11 N14 Q_N N16 0 sky130_fd_pr__npn_05v5_W1p00L1p00
XQ20 GND N13 Q_N 0 sky130_fd_pr__npn_05v5_W1p00L1p00
XQ19 GND N14 Q_P 0 sky130_fd_pr__npn_05v5_W1p00L1p00
XQ7 Q_N V_R N25 0 sky130_fd_pr__npn_05v5_W1p00L1p00
XQ26 Q_P V_R N26 0 sky130_fd_pr__npn_05v5_W1p00L1p00

.control
set filetype=ascii

op
let vdd_current = abs(i(VVDD))
let power_dc = vdd_current * 1.8
print power_dc

ac dec 100 1 10g
let vout_mag = vm(N1)
let gain_db = db(vout_mag)
let dc_gain_db = gain_db[0]
print dc_gain_db

if dc_gain_db > 0
    meas ac ugbw WHEN gain_db=0 CROSS=1
end

quit
.endc

.end
