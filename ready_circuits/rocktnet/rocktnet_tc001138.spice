* Testcase 001138 — Full Analysis (sky130 tt corner)
* SKY130 model header — replaces the ideal level-1 .model cards
* Ships with the demo; the paths point at the local sky130 PDK checkout.
* NOTE: libs.tech/ngspice/all.spice sets ".option scale=1.0u", so every
* instance L/W below is written in microns WITHOUT a "u" suffix.
.param mc_mm_switch=0
.param mc_pr_switch=0
.include /home/idies/workspace/Temporary/xyu1/scratch/skywater-pdk-libs-sky130_fd_pr/models/corners/tt.spice
.include /home/idies/workspace/Temporary/xyu1/scratch/skywater-pdk-libs-sky130_fd_pr/models/r+c/res_typical__cap_typical.spice
.include /home/idies/workspace/Temporary/xyu1/scratch/skywater-pdk-libs-sky130_fd_pr/models/r+c/res_typical__cap_typical__lin.spice
.include /home/idies/workspace/Temporary/xyu1/scratch/skywater-pdk-libs-sky130_fd_pr/models/corners/tt/specialized_cells.spice
.model DIDEAL D   is=1e-14 n=1
.options reltol=1e-3 itl1=500 itl2=100

* Sources

* Circuit
XM1 N1 N2 N4 N4 sky130_fd_pr__nfet_01v8 l=0.5 w=5
XM2 N2 N1 N3 N3 sky130_fd_pr__nfet_01v8 l=0.5 w=5
XM3 N4 N3 N5 N5 sky130_fd_pr__nfet_01v8 l=0.5 w=5
XM4 N3 N4 N5 N5 sky130_fd_pr__nfet_01v8 l=0.5 w=5
XM5 N5 PHI_SAE GND GND sky130_fd_pr__nfet_01v8 l=0.5 w=5

.control
set filetype=ascii

op
let power_dc = 0
print power_dc

let vout_dc = v(N5)
print vout_dc
let vout_dc = v(N2)
print vout_dc
quit
.endc

.end
