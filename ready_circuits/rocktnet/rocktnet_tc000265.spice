* Testcase 000265 — Full Analysis (sky130 tt corner)
* SKY130 model header — replaces the ideal level-1 .model cards
* Ships with the demo; the paths point at the local sky130 PDK checkout.
* NOTE: libs.tech/ngspice/all.spice sets ".option scale=1.0u", so every
* instance L/W below is written in microns WITHOUT a "u" suffix.
.param mc_mm_switch=0
.param mc_pr_switch=0
.include /home/idies/workspace/Temporary/xyu1/scratch/skywater-pdk-libs-sky130_fd_pr/models/corners/tt.spice
.include /home/idies/workspace/Temporary/xyu1/scratch/skywater-pdk-libs-sky130_fd_pr/models/r+c/res_typical__cap_typical.spice
.include /home/idies/workspace/Temporary/xyu1/scratch/skywater-pdk-libs-sky130_fd_pr/models/r+c/res_typical__cap_typical__lin.spice
.include /home/idies/workspace/Temporary/xyu1/scratch/skywater-pdk-libs-sky130_fd_pr/models/corners/tt/specialized_cells.spice
.model DIDEAL D   is=1e-14 n=1
.options reltol=1e-3 itl1=500 itl2=100

* Sources
VVDD VDD 0 1.8

* Circuit
XM4 OUT VDD VDD VDD sky130_fd_pr__pfet_01v8 l=0.5 w=5
I1 N3 GND 1u
I2 VDD N0 1u
I3 N1 GND 1u
XM5 VDD N1 VDD VDD sky130_fd_pr__pfet_01v8 l=0.5 w=5
XM3 VDD VDD VDD VDD sky130_fd_pr__pfet_01v8 l=0.5 w=5
XM12 N0 N0 GND GND sky130_fd_pr__nfet_01v8 l=0.5 w=5
XM7 GND DWN_BAR N4 VDD sky130_fd_pr__pfet_01v8 l=0.5 w=5
I4 VDD N4 1u
XM10 OUT GND GND GND sky130_fd_pr__nfet_01v8 l=0.5 w=5
XM11 GND N0 GND GND sky130_fd_pr__nfet_01v8 l=0.5 w=5
XM6 N1 N1 VDD VDD sky130_fd_pr__pfet_01v8 l=0.5 w=5
XM9 GND GND GND GND sky130_fd_pr__nfet_01v8 l=0.5 w=5
XM2 VDD UP_BAR N3 GND sky130_fd_pr__nfet_01v8 l=0.5 w=5
XM1 VDD UP N3 GND sky130_fd_pr__nfet_01v8 l=0.5 w=5
XM8 GND DWN N4 VDD sky130_fd_pr__pfet_01v8 l=0.5 w=5

.control
set filetype=ascii

op
let power_dc = abs(i(VVDD)) * 1.8
print power_dc

tran 0.1n 100n

let power = abs(i(VVDD)) * 1.8
let avg_power = mean(power)
print avg_power

meas tran vout_max MAX v(OUT)
meas tran vout_min MIN v(OUT)
let vout_swing = vout_max - vout_min
print vout_swing

quit
.endc

.end
