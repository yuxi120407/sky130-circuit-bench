* Testcase 000545 — Full Analysis (sky130 tt corner)
* SKY130 model header — replaces the ideal level-1 .model cards
* Ships with the demo; the paths point at the local sky130 PDK checkout.
* NOTE: libs.tech/ngspice/all.spice sets ".option scale=1.0u", so every
* instance L/W below is written in microns WITHOUT a "u" suffix.
.param mc_mm_switch=0
.param mc_pr_switch=0
.include /home/idies/workspace/Temporary/xyu1/scratch/skywater-pdk-libs-sky130_fd_pr/models/corners/tt.spice
.include /home/idies/workspace/Temporary/xyu1/scratch/skywater-pdk-libs-sky130_fd_pr/models/r+c/res_typical__cap_typical.spice
.include /home/idies/workspace/Temporary/xyu1/scratch/skywater-pdk-libs-sky130_fd_pr/models/r+c/res_typical__cap_typical__lin.spice
.include /home/idies/workspace/Temporary/xyu1/scratch/skywater-pdk-libs-sky130_fd_pr/models/corners/tt/specialized_cells.spice
.model DIDEAL D   is=1e-14 n=1
.options reltol=1e-3 itl1=500 itl2=100

* Sources
VVDD VDD 0 1.8
VIN_PLUS IN_PLUS 0 DC 0.9 AC 1 SIN(0.9 0.1 1MEG 0 0)
VIN_MINUS IN_MINUS 0 DC 0.9 AC 1 SIN(0.9 0.1 1MEG 0 0)

* Circuit
I1 N4 GND 1u
I2 OUT_MINUS GND 1u
I3 OUT_PLUS GND 1u
I4 N1 GND 1u
I5 N5 GND 1u
XM1 N3 N3 VDD VDD sky130_fd_pr__pfet_01v8 l=0.5 w=5
XM2 OUT_PLUS N8 VDD VDD sky130_fd_pr__pfet_01v8 l=0.5 w=5
XM3 N8 N7 VDD VDD sky130_fd_pr__pfet_01v8 l=0.5 w=5
XM5 N7 N7 VDD VDD sky130_fd_pr__pfet_01v8 l=0.5 w=5
XM4 N7 OUT_MINUS N1 GND sky130_fd_pr__nfet_01v8 l=0.5 w=5
R1 N6 OUT_PLUS 10k
R2 N12 OUT_MINUS 10k
XM6 N3 VCOM N1 GND sky130_fd_pr__nfet_01v8 l=0.5 w=5
R3 N13 N7 10k
XM7 N7 OUT_PLUS N5 GND sky130_fd_pr__nfet_01v8 l=0.5 w=5
XM8 N10 N7 VDD VDD sky130_fd_pr__pfet_01v8 l=0.5 w=5
XM9 N3 VCOM N5 GND sky130_fd_pr__nfet_01v8 l=0.5 w=5
XM10 OUT_MINUS N10 VDD VDD sky130_fd_pr__pfet_01v8 l=0.5 w=5
XM11 N8 IN_PLUS N4 GND sky130_fd_pr__nfet_01v8 l=0.5 w=5
XM12 N10 IN_MINUS N4 GND sky130_fd_pr__nfet_01v8 l=0.5 w=5
C1 OUT_PLUS N6 1p
C2 VDD N13 1p
C3 OUT_MINUS N12 1p

.control
set filetype=ascii

op
let power_dc = abs(i(VVDD)) * 1.8
print power_dc

ac dec 100 1 10g
let vout_mag = vm(N4)
let gain_db = db(vout_mag)
let dc_gain_db = gain_db[0]
print dc_gain_db

if dc_gain_db > 0
    meas ac ugbw WHEN gain_db=0 CROSS=1
    print ugbw
end

quit
.endc

.end
