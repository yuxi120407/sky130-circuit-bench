* Testcase 000268 — Full Analysis (sky130 tt corner)
* SKY130 model header — replaces the ideal level-1 .model cards
* Ships with the demo; the paths point at the local sky130 PDK checkout.
* NOTE: libs.tech/ngspice/all.spice sets ".option scale=1.0u", so every
* instance L/W below is written in microns WITHOUT a "u" suffix.
.param mc_mm_switch=0
.param mc_pr_switch=0
.include /home/idies/workspace/Temporary/xyu1/scratch/skywater-pdk-libs-sky130_fd_pr/models/corners/tt.spice
.include /home/idies/workspace/Temporary/xyu1/scratch/skywater-pdk-libs-sky130_fd_pr/models/r+c/res_typical__cap_typical.spice
.include /home/idies/workspace/Temporary/xyu1/scratch/skywater-pdk-libs-sky130_fd_pr/models/r+c/res_typical__cap_typical__lin.spice
.include /home/idies/workspace/Temporary/xyu1/scratch/skywater-pdk-libs-sky130_fd_pr/models/corners/tt/specialized_cells.spice
.model DIDEAL D   is=1e-14 n=1
.options reltol=1e-3 itl1=500 itl2=100

* Sources
VVDD VDD 0 1.8
VVB VB 0 DC 0.9900000000000001 AC 1

* Circuit
XM1 IO_PLUS VI_MINUS GND GND sky130_fd_pr__nfet_01v8 l=0.5 w=5
XM2 IO_MINUS VI_PLUS GND GND sky130_fd_pr__nfet_01v8 l=0.5 w=5
XM3 IO_PLUS VB VDD VDD sky130_fd_pr__pfet_01v8 l=0.5 w=5
XM4 IO_MINUS VB VDD VDD sky130_fd_pr__pfet_01v8 l=0.5 w=5

.control
set filetype=ascii

op
let power_dc = abs(i(VVDD)) * 1.8
print power_dc

ac dec 100 1 10g
let gain_VI_PLUS = db(vm(VI_PLUS))
let gain_IO_MINUS = db(vm(IO_MINUS))
let gain_IO_PLUS = db(vm(IO_PLUS))
let gain_VI_MINUS = db(vm(VI_MINUS))
meas ac max_gain_VI_PLUS MAX gain_VI_PLUS
meas ac max_gain_IO_MINUS MAX gain_IO_MINUS
meas ac max_gain_IO_PLUS MAX gain_IO_PLUS
meas ac max_gain_VI_MINUS MAX gain_VI_MINUS

* Use first probe node for standard metrics
let gain_db = db(vm(VI_PLUS))
meas ac dc_gain_db FIND gain_db AT=1
meas ac ugbw WHEN gain_db=0 CROSS=1
let vout_dc = v(VI_PLUS)

print dc_gain_db ugbw vout_dc gain_VI_PLUS gain_IO_MINUS gain_IO_PLUS gain_VI_MINUS

quit
.endc

.end
