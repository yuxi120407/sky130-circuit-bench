* Testcase 000684 — Full Analysis (sky130 tt corner)
* SKY130 model header — replaces the ideal level-1 .model cards
* Ships with the demo; the paths point at the local sky130 PDK checkout.
* NOTE: libs.tech/ngspice/all.spice sets ".option scale=1.0u", so every
* instance L/W below is written in microns WITHOUT a "u" suffix.
.param mc_mm_switch=0
.param mc_pr_switch=0
.include /home/idies/workspace/Temporary/xyu1/scratch/skywater-pdk-libs-sky130_fd_pr/models/corners/tt.spice
.include /home/idies/workspace/Temporary/xyu1/scratch/skywater-pdk-libs-sky130_fd_pr/models/r+c/res_typical__cap_typical.spice
.include /home/idies/workspace/Temporary/xyu1/scratch/skywater-pdk-libs-sky130_fd_pr/models/r+c/res_typical__cap_typical__lin.spice
.include /home/idies/workspace/Temporary/xyu1/scratch/skywater-pdk-libs-sky130_fd_pr/models/corners/tt/specialized_cells.spice
.model DIDEAL D   is=1e-14 n=1
.options reltol=1e-3 itl1=500 itl2=100

* Sources
VVDD VDD 0 1.8
VLABEL_NET_0 LABEL_NET_0 0 0.9
VLABEL_NET_1 LABEL_NET_1 0 DC 0.9 AC 1
VLABEL_NET_2 LABEL_NET_2 0 0.9
VLABEL_NET_3 LABEL_NET_3 0 0.9
VLABEL_NET_4 LABEL_NET_4 0 0.9
VLABEL_NET_5 LABEL_NET_5 0 0.9

* Circuit
XM1 N9 N2 VDD VDD sky130_fd_pr__pfet_01v8 l=0.5 w=5
XM2 N10 N8 N4 GND sky130_fd_pr__nfet_01v8 l=0.5 w=5
XM3 N0 LABEL_NET_0 N3 VDD sky130_fd_pr__pfet_01v8 l=0.5 w=5
XM4 N13 N18 VDD VDD sky130_fd_pr__pfet_01v8 l=0.5 w=5
XM5 N15 N18 N4 GND sky130_fd_pr__nfet_01v8 l=0.5 w=5
XM6 N1 N12 N4 GND sky130_fd_pr__nfet_01v8 l=0.5 w=5
XM7 N16 N8 VDD VDD sky130_fd_pr__pfet_01v8 l=0.5 w=5
XM8 N0 N17 N9 VDD sky130_fd_pr__pfet_01v8 l=0.5 w=5
XM9 N0 N17 N4 GND sky130_fd_pr__nfet_01v8 l=0.5 w=5
XM10 N12 N0 VDD VDD sky130_fd_pr__pfet_01v8 l=0.5 w=5
XM11 N17 LABEL_NET_1 N11 GND sky130_fd_pr__nfet_01v8 l=0.5 w=5
XM12 N11 N7 N10 GND sky130_fd_pr__nfet_01v8 l=0.5 w=5
XM13 N17 LABEL_NET_2 N16 VDD sky130_fd_pr__pfet_01v8 l=0.5 w=5
XM14 N18 N6 N5 VDD sky130_fd_pr__pfet_01v8 l=0.5 w=5
XM15 N0 N2 N4 GND sky130_fd_pr__nfet_01v8 l=0.5 w=5
XM16 N3 LABEL_NET_3 VDD VDD sky130_fd_pr__pfet_01v8 l=0.5 w=5
XM17 N0 LABEL_NET_4 N1 GND sky130_fd_pr__nfet_01v8 l=0.5 w=5
XM18 N5 N18 VDD VDD sky130_fd_pr__pfet_01v8 l=0.5 w=5
XM19 N18 N14 N15 GND sky130_fd_pr__nfet_01v8 l=0.5 w=5
XM20 N18 LABEL_NET_5 VDD VDD sky130_fd_pr__pfet_01v8 l=0.5 w=5
XM21 N16 N7 VDD VDD sky130_fd_pr__pfet_01v8 l=0.5 w=5
XM22 N13 N18 N4 GND sky130_fd_pr__nfet_01v8 l=0.5 w=5
XM23 N12 N0 N4 GND sky130_fd_pr__nfet_01v8 l=0.5 w=5
XM24 N18 N6 N18 GND sky130_fd_pr__nfet_01v8 l=0.5 w=5
XM25 N18 N14 N12 VDD sky130_fd_pr__pfet_01v8 l=0.5 w=5

.control
set filetype=ascii

op
let power_dc = abs(i(VVDD)) * 1.8
print power_dc

ac dec 100 1 10g
let gain_N1 = db(vm(N1))
let gain_N7 = db(vm(N7))
let gain_N17 = db(vm(N17))
let gain_N16 = db(vm(N16))
let gain_N5 = db(vm(N5))
meas ac max_gain_N1 MAX gain_N1
meas ac max_gain_N7 MAX gain_N7
meas ac max_gain_N17 MAX gain_N17
meas ac max_gain_N16 MAX gain_N16
meas ac max_gain_N5 MAX gain_N5

* Use first probe node for standard metrics
let gain_db = db(vm(N1))
meas ac dc_gain_db FIND gain_db AT=1
meas ac ugbw WHEN gain_db=0 CROSS=1
let vout_dc = v(N1)

print dc_gain_db ugbw vout_dc gain_N1 gain_N7 gain_N17 gain_N16 gain_N5

quit
.endc

.end
