* Testcase 000523 — Full Analysis (sky130 tt corner)
* SKY130 model header — replaces the ideal level-1 .model cards
* Ships with the demo; the paths point at the local sky130 PDK checkout.
* NOTE: libs.tech/ngspice/all.spice sets ".option scale=1.0u", so every
* instance L/W below is written in microns WITHOUT a "u" suffix.
.param mc_mm_switch=0
.param mc_pr_switch=0
.include /home/idies/workspace/Temporary/xyu1/scratch/skywater-pdk-libs-sky130_fd_pr/models/corners/tt.spice
.include /home/idies/workspace/Temporary/xyu1/scratch/skywater-pdk-libs-sky130_fd_pr/models/r+c/res_typical__cap_typical.spice
.include /home/idies/workspace/Temporary/xyu1/scratch/skywater-pdk-libs-sky130_fd_pr/models/r+c/res_typical__cap_typical__lin.spice
.include /home/idies/workspace/Temporary/xyu1/scratch/skywater-pdk-libs-sky130_fd_pr/models/corners/tt/specialized_cells.spice
.model DIDEAL D   is=1e-14 n=1
.options reltol=1e-3 itl1=500 itl2=100

* Sources
VVDD VDD 0 1.8

* Circuit
XM1 N0 N1 VDD VDD sky130_fd_pr__pfet_01v8 l=0.5 w=5
XM2 N1 N0 VDD VDD sky130_fd_pr__pfet_01v8 l=0.5 w=5
XP1 SENSE PRE_BAR VDD VDD sky130_fd_pr__pfet_01v8 l=0.5 w=5
XM4 N1 N0 GND GND sky130_fd_pr__nfet_01v8 l=0.5 w=5
XM5 N0 N1 GND GND sky130_fd_pr__nfet_01v8 l=0.5 w=5
XN1 BL PRE VDD VDD sky130_fd_pr__pfet_01v8 l=0.5 w=5
XP0 OUT SENSE VDD VDD sky130_fd_pr__pfet_01v8 l=0.5 w=5
XN0 OUT SENSE GND GND sky130_fd_pr__nfet_01v8 l=0.5 w=5
XM9 BL VDD N1 GND sky130_fd_pr__nfet_01v8 l=0.5 w=5
XN2 SENSE VDD BL GND sky130_fd_pr__nfet_01v8 l=0.5 w=5

.control
set filetype=ascii

op
let power_dc = abs(i(VVDD)) * 1.8
print power_dc

tran 0.1n 100n

let power = abs(i(VVDD)) * 1.8
let avg_power = mean(power)
print avg_power

meas tran vout_max MAX v(OUT)
meas tran vout_min MIN v(OUT)
let vout_swing = vout_max - vout_min
print vout_swing

quit
.endc

.end
