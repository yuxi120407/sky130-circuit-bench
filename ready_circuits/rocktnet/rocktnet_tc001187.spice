* Testcase 001187 — Full Analysis (sky130 tt corner)
* SKY130 model header — replaces the ideal level-1 .model cards
* Ships with the demo; the paths point at the local sky130 PDK checkout.
* NOTE: libs.tech/ngspice/all.spice sets ".option scale=1.0u", so every
* instance L/W below is written in microns WITHOUT a "u" suffix.
.param mc_mm_switch=0
.param mc_pr_switch=0
.include /home/idies/workspace/Temporary/xyu1/scratch/skywater-pdk-libs-sky130_fd_pr/models/corners/tt.spice
.include /home/idies/workspace/Temporary/xyu1/scratch/skywater-pdk-libs-sky130_fd_pr/models/r+c/res_typical__cap_typical.spice
.include /home/idies/workspace/Temporary/xyu1/scratch/skywater-pdk-libs-sky130_fd_pr/models/r+c/res_typical__cap_typical__lin.spice
.include /home/idies/workspace/Temporary/xyu1/scratch/skywater-pdk-libs-sky130_fd_pr/models/corners/tt/specialized_cells.spice
.model DIDEAL D   is=1e-14 n=1
.options reltol=1e-3 itl1=500 itl2=100

* Sources
VVDD VDD 0 1.8
VINN INN 0 DC 0.9 AC 1 SIN(0.9 0.1 1MEG 0 0)
VINP INP 0 DC 0.9 AC 1 SIN(0.9 0.1 1MEG 0 0)

* Circuit
L1 VDD N8 10n
L2 VDD N3 10n
L3 VDD N2 10n
XM1 N3 N10 N7 GND sky130_fd_pr__nfet_01v8 l=0.5 w=5
R1 N10 BIAS 10k
L4 N12 GND 10n
L5 VDD N11 10n
R2 VDD N9 10k
R3 N6 BIAS 10k
L6 N13 GND 10n
XM2 N11 N6 N7 GND sky130_fd_pr__nfet_01v8 l=0.5 w=5
XM3 N5 INN N0 GND sky130_fd_pr__nfet_01v8 l=0.5 w=5
XM4 N0 BIAS GND GND sky130_fd_pr__nfet_01v8 l=0.5 w=5
XM5 N4 INP N0 GND sky130_fd_pr__nfet_01v8 l=0.5 w=5
XM6 N2 N9 N4 GND sky130_fd_pr__nfet_01v8 l=0.5 w=5
XM7 N8 N9 N5 GND sky130_fd_pr__nfet_01v8 l=0.5 w=5
L7 N7 GND 10n
C1 N6 N8 1p
C2 N12 OUTP 1p
C3 N13 OUTN 1p
C4 N2 N10 1p
C5 N3 N13 1p
C6 N11 N12 1p

.control
set filetype=ascii

op
let vdd_current = abs(i(VVDD))
let power_dc = vdd_current * 1.8
print power_dc

ac dec 100 1k 100g
let vout_mag = vm(OUTP)
let gain_db = db(vout_mag)

meas ac max_gain_db MAX gain_db
meas ac bw_3db WHEN gain_db='max_gain_db-3' CROSS=1

print max_gain_db bw_3db

quit
.endc

.end
