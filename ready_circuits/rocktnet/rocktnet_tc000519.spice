* Testcase 000519 — Full Analysis (sky130 tt corner)
* SKY130 model header — replaces the ideal level-1 .model cards
* Ships with the demo; the paths point at the local sky130 PDK checkout.
* NOTE: libs.tech/ngspice/all.spice sets ".option scale=1.0u", so every
* instance L/W below is written in microns WITHOUT a "u" suffix.
.param mc_mm_switch=0
.param mc_pr_switch=0
.include /home/idies/workspace/Temporary/xyu1/scratch/skywater-pdk-libs-sky130_fd_pr/models/corners/tt.spice
.include /home/idies/workspace/Temporary/xyu1/scratch/skywater-pdk-libs-sky130_fd_pr/models/r+c/res_typical__cap_typical.spice
.include /home/idies/workspace/Temporary/xyu1/scratch/skywater-pdk-libs-sky130_fd_pr/models/r+c/res_typical__cap_typical__lin.spice
.include /home/idies/workspace/Temporary/xyu1/scratch/skywater-pdk-libs-sky130_fd_pr/models/corners/tt/specialized_cells.spice
.model DIDEAL D   is=1e-14 n=1
.options reltol=1e-3 itl1=500 itl2=100

* Sources
VVIN_POS VIN_POS 0 DC 0.9 AC 1 SIN(0.9 0.1 1MEG 0 0)
VVIN_NEG VIN_NEG 0 DC 0.9 AC 1 SIN(0.9 0.1 1MEG 0 0)

* Circuit
R1 VOUT_P N6 10k
XM1 VCC N6 VOUT_P GND sky130_fd_pr__nfet_01v8 l=0.5 w=5
R2 VOUT_N N6 10k
XQ1 VOUT_P VD_NEG N3 0 sky130_fd_pr__npn_05v5_W1p00L1p00
XQ2 VOUT_N VD_NEG N0 0 sky130_fd_pr__npn_05v5_W1p00L1p00
XQ3 VCC VD_POS N0 0 sky130_fd_pr__npn_05v5_W1p00L1p00
XQ4 VCC VD_POS N3 0 sky130_fd_pr__npn_05v5_W1p00L1p00
XM2 VCC N6 VOUT_N GND sky130_fd_pr__nfet_01v8 l=0.5 w=5

.control
set filetype=ascii

op
let power_dc = abs(i(VVIN_POS)) * 1.8
print power_dc
let dc_voltage = v(N6)
print dc_voltage

quit
.endc

.end
