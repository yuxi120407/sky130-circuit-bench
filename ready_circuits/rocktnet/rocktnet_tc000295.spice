* Testcase 000295 — Full Analysis (sky130 tt corner)
* SKY130 model header — replaces the ideal level-1 .model cards
* Ships with the demo; the paths point at the local sky130 PDK checkout.
* NOTE: libs.tech/ngspice/all.spice sets ".option scale=1.0u", so every
* instance L/W below is written in microns WITHOUT a "u" suffix.
.param mc_mm_switch=0
.param mc_pr_switch=0
.include /home/idies/workspace/Temporary/xyu1/scratch/skywater-pdk-libs-sky130_fd_pr/models/corners/tt.spice
.include /home/idies/workspace/Temporary/xyu1/scratch/skywater-pdk-libs-sky130_fd_pr/models/r+c/res_typical__cap_typical.spice
.include /home/idies/workspace/Temporary/xyu1/scratch/skywater-pdk-libs-sky130_fd_pr/models/r+c/res_typical__cap_typical__lin.spice
.include /home/idies/workspace/Temporary/xyu1/scratch/skywater-pdk-libs-sky130_fd_pr/models/corners/tt/specialized_cells.spice
.model DIDEAL D   is=1e-14 n=1
.options reltol=1e-3 itl1=500 itl2=100

* Sources
VVDD VDD 0 1.8
VIN_MINUS IN_MINUS 0 DC 0.9 AC -0.5
VIN_PLUS IN_PLUS 0 DC 0.9 AC 0.5

* Circuit
I1 N2 GND 1u
XM1 OUT_PLUS IN_MINUS N4 VDD sky130_fd_pr__pfet_01v8 l=0.5 w=5
XM2 N3 N11 GND GND sky130_fd_pr__nfet_01v8 l=0.5 w=5
XM3 N4 N2 VDD VDD sky130_fd_pr__pfet_01v8 l=0.5 w=5
XM4 OUT_MINUS OUT_MINUS N9 GND sky130_fd_pr__nfet_01v8 l=0.5 w=5
XM5 N12 OUT_PLUS N0 GND sky130_fd_pr__nfet_01v8 l=0.5 w=5
XM6 OUT_PLUS OUT_PLUS N6 GND sky130_fd_pr__nfet_01v8 l=0.5 w=5
XM7 N12 OUT_MINUS N0 GND sky130_fd_pr__nfet_01v8 l=0.5 w=5
XM8 OUT_MINUS N11 GND GND sky130_fd_pr__nfet_01v8 l=0.5 w=5
XM9 N0 N0 GND GND sky130_fd_pr__nfet_01v8 l=0.5 w=5
XM10 N2 N2 VDD VDD sky130_fd_pr__pfet_01v8 l=0.5 w=5
XM11 OUT_PLUS N11 GND GND sky130_fd_pr__nfet_01v8 l=0.5 w=5
XM12 OUT_MINUS IN_PLUS N4 VDD sky130_fd_pr__pfet_01v8 l=0.5 w=5
XM13 N7 CTRL N3 VDD sky130_fd_pr__pfet_01v8 l=0.5 w=5
XM14 N3 VDD N10 GND sky130_fd_pr__nfet_01v8 l=0.5 w=5
XM15 N7 VDD N6 VDD sky130_fd_pr__pfet_01v8 l=0.5 w=5
XM16 N7 VDD N3 GND sky130_fd_pr__nfet_01v8 l=0.5 w=5
XM17 N3 CTRL N3 GND sky130_fd_pr__nfet_01v8 l=0.5 w=5
XM18 N10 VDD N9 GND sky130_fd_pr__nfet_01v8 l=0.5 w=5

.control
set filetype=ascii

op
let power_dc = abs(i(VVDD)) * 1.8
let vout_dc = v(OUT_PLUS)
print power_dc vout_dc

ac dec 100 1 10g
let gain_db = db(vm(OUT_PLUS))
meas ac dc_gain_db FIND gain_db AT=1
meas ac ugbw WHEN gain_db=0 CROSS=1
print dc_gain_db ugbw

quit
.endc

.end
