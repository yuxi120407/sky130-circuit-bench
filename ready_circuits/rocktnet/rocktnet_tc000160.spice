* Testcase 000160 — Full Analysis (sky130 tt corner)
* SKY130 model header — replaces the ideal level-1 .model cards
* Ships with the demo; the paths point at the local sky130 PDK checkout.
* NOTE: libs.tech/ngspice/all.spice sets ".option scale=1.0u", so every
* instance L/W below is written in microns WITHOUT a "u" suffix.
.param mc_mm_switch=0
.param mc_pr_switch=0
.include /home/idies/workspace/Temporary/xyu1/scratch/skywater-pdk-libs-sky130_fd_pr/models/corners/tt.spice
.include /home/idies/workspace/Temporary/xyu1/scratch/skywater-pdk-libs-sky130_fd_pr/models/r+c/res_typical__cap_typical.spice
.include /home/idies/workspace/Temporary/xyu1/scratch/skywater-pdk-libs-sky130_fd_pr/models/r+c/res_typical__cap_typical__lin.spice
.include /home/idies/workspace/Temporary/xyu1/scratch/skywater-pdk-libs-sky130_fd_pr/models/corners/tt/specialized_cells.spice
.model DIDEAL D   is=1e-14 n=1
.options reltol=1e-3 itl1=500 itl2=100

* Sources
VVDD VDD 0 1.8
VVSS VSS 0 0
VVREF VREF 0 0.9
VVIN VIN 0 DC 0.9 AC 1 SIN(0.9 0.1 1MEG 0 0)
VVCMFB VCMFB 0 0.9
VVB VB 0 0.9900000000000001

* Circuit
XM1 N_OUT VIP N_TAIL1 VDD sky130_fd_pr__pfet_01v8 l=0.5 w=5
XM2 N_MIRROR VREF N_TAIL1 VDD sky130_fd_pr__pfet_01v8 l=0.5 w=5
XM3 N_MIRROR VREF N_TAIL2 VDD sky130_fd_pr__pfet_01v8 l=0.5 w=5
XM4 N_OUT VIN N_TAIL2 VDD sky130_fd_pr__pfet_01v8 l=0.5 w=5
XM5 N_MIRROR N_MIRROR VSS VSS sky130_fd_pr__nfet_01v8 l=0.5 w=5
XM6 N_MIRROR N_MIRROR VSS VSS sky130_fd_pr__nfet_01v8 l=0.5 w=5
XM7 N_OUT N_MIRROR VSS VSS sky130_fd_pr__nfet_01v8 l=0.5 w=5
XM8 N_OUT VCMFB VDD VDD sky130_fd_pr__pfet_01v8 l=0.5 w=5
XM9 VB VB VDD VDD sky130_fd_pr__pfet_01v8 l=0.5 w=5
XM10 N_TAIL1 VB VDD VDD sky130_fd_pr__pfet_01v8 l=0.5 w=5
XM11 N_TAIL2 VB VDD VDD sky130_fd_pr__pfet_01v8 l=0.5 w=5
I1 VB VSS 1u

.control
set filetype=ascii

op
let vdd_current = abs(i(VVDD))
let power_dc = vdd_current * 1.8
print power_dc

print all

quit
.endc

.end
