* Testcase 000728 — Full Analysis (sky130 tt corner)
* SKY130 model header — replaces the ideal level-1 .model cards
* Ships with the demo; the paths point at the local sky130 PDK checkout.
* NOTE: libs.tech/ngspice/all.spice sets ".option scale=1.0u", so every
* instance L/W below is written in microns WITHOUT a "u" suffix.
.param mc_mm_switch=0
.param mc_pr_switch=0
.include /home/idies/workspace/Temporary/xyu1/scratch/skywater-pdk-libs-sky130_fd_pr/models/corners/tt.spice
.include /home/idies/workspace/Temporary/xyu1/scratch/skywater-pdk-libs-sky130_fd_pr/models/r+c/res_typical__cap_typical.spice
.include /home/idies/workspace/Temporary/xyu1/scratch/skywater-pdk-libs-sky130_fd_pr/models/r+c/res_typical__cap_typical__lin.spice
.include /home/idies/workspace/Temporary/xyu1/scratch/skywater-pdk-libs-sky130_fd_pr/models/corners/tt/specialized_cells.spice
.model DIDEAL D   is=1e-14 n=1
.options reltol=1e-3 itl1=500 itl2=100

* Sources
VVDD VDD 0 1.8
VINPUT INPUT 0 DC 0.9 AC 1 SIN(0.9 0.1 1MEG 0 0)

* Circuit
L2 VDD N2 10n
R01 VDD N0 10k
R11 N4 GND 10k
R02 BACKPLANE N8 10k
L1 N3 GND 10n
CJ1 N0 N2 1p
CJ3 OUTPUT N4 1p
C02 VDD N5 1p
CJ2 N0 OUTPUT 1p
C01 N0 N8 1p
R13 BACKPLANE GND 10k
R03 N5 BACKPLANE 10k
CJ4 N3 N4 1p
R12 N4 BACKPLANE 10k
XM1 N9 INPUT N3 N4 sky130_fd_pr__nfet_01v8 l=0.5 w=5
XM2 N2 INPUT N9 N0 sky130_fd_pr__nfet_01v8 l=0.5 w=5

.control
set filetype=ascii

op
let vdd_current = abs(i(VVDD))
let power_dc = vdd_current * 1.8
print power_dc

ac dec 100 1k 100g
let vout_mag = vm(OUTPUT)
let gain_db = db(vout_mag)

meas ac max_gain_db MAX gain_db
meas ac bw_3db WHEN gain_db='max_gain_db-3' CROSS=1

print max_gain_db bw_3db

quit
.endc

.end
