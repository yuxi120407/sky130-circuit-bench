* Testcase 000183 — Full Analysis (sky130 tt corner)
* SKY130 model header — replaces the ideal level-1 .model cards
* Ships with the demo; the paths point at the local sky130 PDK checkout.
* NOTE: libs.tech/ngspice/all.spice sets ".option scale=1.0u", so every
* instance L/W below is written in microns WITHOUT a "u" suffix.
.param mc_mm_switch=0
.param mc_pr_switch=0
.include /home/idies/workspace/Temporary/xyu1/scratch/skywater-pdk-libs-sky130_fd_pr/models/corners/tt.spice
.include /home/idies/workspace/Temporary/xyu1/scratch/skywater-pdk-libs-sky130_fd_pr/models/r+c/res_typical__cap_typical.spice
.include /home/idies/workspace/Temporary/xyu1/scratch/skywater-pdk-libs-sky130_fd_pr/models/r+c/res_typical__cap_typical__lin.spice
.include /home/idies/workspace/Temporary/xyu1/scratch/skywater-pdk-libs-sky130_fd_pr/models/corners/tt/specialized_cells.spice
.model DIDEAL D   is=1e-14 n=1
.options reltol=1e-3 itl1=500 itl2=100

* Sources
VIN IN 0 DC 0.9 AC 1 SIN(0.9 0.1 1MEG 0 0)

* Circuit
I1 N4 N3 1u
XM7 N6 IN N8 N8 sky130_fd_pr__nfet_01v8 l=0.5 w=5
I2 N4 N2 1u
XM6 N3 N9 N5 N5 sky130_fd_pr__nfet_01v8 l=0.5 w=5
XM3 OUT OUT N8 N8 sky130_fd_pr__nfet_01v8 l=0.5 w=5
XM4 N7 N7 N8 N8 sky130_fd_pr__nfet_01v8 l=0.5 w=5
XM5 N5 N5 N8 N8 sky130_fd_pr__nfet_01v8 l=0.5 w=5
XM2 OUT N1 N4 N4 sky130_fd_pr__pfet_01v8 l=0.5 w=5
XM1 N4 N9 N6 N6 sky130_fd_pr__nfet_01v8 l=0.5 w=5
XM8 N2 N1 N7 N7 sky130_fd_pr__nfet_01v8 l=0.5 w=5
XM9 N6 SW OUT OUT sky130_fd_pr__nfet_01v8 l=0.5 w=5

.control
set filetype=ascii

op
let vdd_current = abs(i(VVDD))
let power_dc = vdd_current * 1.8
print power_dc

ac dec 100 1 10g
let vout_mag = vm(OUT)
let gain_db = db(vout_mag)
let dc_gain_db = gain_db[0]
print dc_gain_db

if dc_gain_db > 0
    meas ac ugbw WHEN gain_db=0 CROSS=1
end

quit
.endc

.end
