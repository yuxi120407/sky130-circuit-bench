* Testcase 000299 — Full Analysis (sky130 tt corner)
* SKY130 model header — replaces the ideal level-1 .model cards
* Ships with the demo; the paths point at the local sky130 PDK checkout.
* NOTE: libs.tech/ngspice/all.spice sets ".option scale=1.0u", so every
* instance L/W below is written in microns WITHOUT a "u" suffix.
.param mc_mm_switch=0
.param mc_pr_switch=0
.include /home/idies/workspace/Temporary/xyu1/scratch/skywater-pdk-libs-sky130_fd_pr/models/corners/tt.spice
.include /home/idies/workspace/Temporary/xyu1/scratch/skywater-pdk-libs-sky130_fd_pr/models/r+c/res_typical__cap_typical.spice
.include /home/idies/workspace/Temporary/xyu1/scratch/skywater-pdk-libs-sky130_fd_pr/models/r+c/res_typical__cap_typical__lin.spice
.include /home/idies/workspace/Temporary/xyu1/scratch/skywater-pdk-libs-sky130_fd_pr/models/corners/tt/specialized_cells.spice
.model DIDEAL D   is=1e-14 n=1
.options reltol=1e-3 itl1=500 itl2=100

* Sources
VVDD VDD 0 1.8

* Circuit
I1 VIF_Q_P GND 1u
XM5 VDD VLO2_P N0 GND sky130_fd_pr__nfet_01v8 l=0.5 w=5
XM6 VRF VLO2_N N0 GND sky130_fd_pr__nfet_01v8 l=0.5 w=5
XM7 VDD VLO2_N N1 GND sky130_fd_pr__nfet_01v8 l=0.5 w=5
LD VDD VRF 10n
XM3 N0 VIF_Q_P VIF_Q_P GND sky130_fd_pr__nfet_01v8 l=0.5 w=5
XM1 N0 VIF_I_P VIF_Q_P GND sky130_fd_pr__nfet_01v8 l=0.5 w=5
XM2 N1 VIF_I_N VIF_Q_P GND sky130_fd_pr__nfet_01v8 l=0.5 w=5
XM4 N1 VIF_Q_N VIF_Q_P GND sky130_fd_pr__nfet_01v8 l=0.5 w=5
XM8 VRF VLO2_P N1 GND sky130_fd_pr__nfet_01v8 l=0.5 w=5
CB VIF_Q_P GND 1p

.control
set filetype=ascii

op
let vdd_current = abs(i(VVDD))
let power_dc = vdd_current * 1.8
print power_dc

ac dec 100 1k 100g
let vout_mag = vm(VIF_Q_P)
let gain_db = db(vout_mag)

meas ac max_gain_db MAX gain_db
meas ac bw_3db WHEN gain_db='max_gain_db-3' CROSS=1

print max_gain_db bw_3db

quit
.endc

.end
