* Testcase 000009 — Full Analysis (sky130 tt corner)
* SKY130 model header — replaces the ideal level-1 .model cards
* Ships with the demo; the paths point at the local sky130 PDK checkout.
* NOTE: libs.tech/ngspice/all.spice sets ".option scale=1.0u", so every
* instance L/W below is written in microns WITHOUT a "u" suffix.
.param mc_mm_switch=0
.param mc_pr_switch=0
.include /home/idies/workspace/Temporary/xyu1/scratch/skywater-pdk-libs-sky130_fd_pr/models/corners/tt.spice
.include /home/idies/workspace/Temporary/xyu1/scratch/skywater-pdk-libs-sky130_fd_pr/models/r+c/res_typical__cap_typical.spice
.include /home/idies/workspace/Temporary/xyu1/scratch/skywater-pdk-libs-sky130_fd_pr/models/r+c/res_typical__cap_typical__lin.spice
.include /home/idies/workspace/Temporary/xyu1/scratch/skywater-pdk-libs-sky130_fd_pr/models/corners/tt/specialized_cells.spice
.model DIDEAL D   is=1e-14 n=1
.options reltol=1e-3 itl1=500 itl2=100

* Sources
VVDD VDD 0 1.8

* Circuit
I1 N4 GND 1u
XM1 N2 N7 N4 GND sky130_fd_pr__nfet_01v8 l=0.5 w=5
XM2 N5 N3 N4 GND sky130_fd_pr__nfet_01v8 l=0.5 w=5
XM3 N2 N8 N4 GND sky130_fd_pr__nfet_01v8 l=0.5 w=5
R1 N1 N3 10k
XM4 N5 N6 N4 GND sky130_fd_pr__nfet_01v8 l=0.5 w=5
R2 VDD N5 10k
R3 N0 N6 10k
R4 N0 N1 10k
R5 N1 N1 10k
R6 N1 N8 10k
R7 N1 N7 10k
C1 N1 N7 1p
C2 N1 GND 1p
C3 N3 GND 1p
R8 VDD N2 10k
C4 N2 N5 1p
C5 N0 N8 1p
C6 N6 GND 1p

.control
set filetype=ascii

op
let vdd_current = abs(i(VVDD))
let power_dc = vdd_current * 1.8
print power_dc

print all

let vout_dc = v(N4)
print vout_dc
let vout_dc = v(N2)
print vout_dc
quit
.endc

.end
