* Testcase 001035 — Full Analysis (sky130 tt corner)
* SKY130 model header — replaces the ideal level-1 .model cards
* Ships with the demo; the paths point at the local sky130 PDK checkout.
* NOTE: libs.tech/ngspice/all.spice sets ".option scale=1.0u", so every
* instance L/W below is written in microns WITHOUT a "u" suffix.
.param mc_mm_switch=0
.param mc_pr_switch=0
.include /home/idies/workspace/Temporary/xyu1/scratch/skywater-pdk-libs-sky130_fd_pr/models/corners/tt.spice
.include /home/idies/workspace/Temporary/xyu1/scratch/skywater-pdk-libs-sky130_fd_pr/models/r+c/res_typical__cap_typical.spice
.include /home/idies/workspace/Temporary/xyu1/scratch/skywater-pdk-libs-sky130_fd_pr/models/r+c/res_typical__cap_typical__lin.spice
.include /home/idies/workspace/Temporary/xyu1/scratch/skywater-pdk-libs-sky130_fd_pr/models/corners/tt/specialized_cells.spice
.model DIDEAL D   is=1e-14 n=1
.options reltol=1e-3 itl1=500 itl2=100

* Sources
VVDD VDD 0 1.8
VLABEL_NET_3 LABEL_NET_3 0 DC 0.9 AC 0.5
VLABEL_NET_2 LABEL_NET_2 0 DC 0.9 AC -0.5
VLABEL_NET_4 LABEL_NET_4 0 0.9
VLABEL_NET_5 LABEL_NET_5 0 0.9

* Circuit
I1 N7 GND 1u
XM1 N4 N3 N2 VDD sky130_fd_pr__pfet_01v8 l=0.5 w=5
XM2 N6 N0 N2 VDD sky130_fd_pr__pfet_01v8 l=0.5 w=5
XM3 N4 N10 GND GND sky130_fd_pr__nfet_01v8 l=0.5 w=5
XM4 LABEL_NET_3 N3 LABEL_NET_2 VDD sky130_fd_pr__pfet_01v8 l=0.5 w=5
XM5 N7 N7 LABEL_NET_4 VDD sky130_fd_pr__pfet_01v8 l=0.5 w=5
XM6 N6 N1 GND GND sky130_fd_pr__nfet_01v8 l=0.5 w=5
XM7 N1 N1 GND GND sky130_fd_pr__nfet_01v8 l=0.5 w=5
XM8 N0 N5 N6 GND sky130_fd_pr__nfet_01v8 l=0.5 w=5
XM9 N3 N9 LABEL_NET_5 VDD sky130_fd_pr__pfet_01v8 l=0.5 w=5
XM10 N0 N14 N9 VDD sky130_fd_pr__pfet_01v8 l=0.5 w=5
XM11 N3 N2 N4 GND sky130_fd_pr__nfet_01v8 l=0.5 w=5
XM12 N1 N7 N14 VDD sky130_fd_pr__pfet_01v8 l=0.5 w=5
R1 N11 N12 10k
R2 N4 N6 10k
C1 N2 N5 1p
C2 N13 GND 1p

.control
set filetype=ascii

op
let vdd_current = abs(i(VVDD))
let power_dc = vdd_current * 1.8
print power_dc

ac dec 100 1 10g
let vout_mag = vm(N13)
let gain_db = db(vout_mag)
let dc_gain_db = gain_db[0]
print dc_gain_db

if dc_gain_db > 0
    meas ac ugbw WHEN gain_db=0 CROSS=1
end

quit
.endc

.end
