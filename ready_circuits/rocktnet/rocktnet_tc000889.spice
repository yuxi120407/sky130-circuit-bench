* Testcase 000889 — Full Analysis (sky130 tt corner)
* SKY130 model header — replaces the ideal level-1 .model cards
* Ships with the demo; the paths point at the local sky130 PDK checkout.
* NOTE: libs.tech/ngspice/all.spice sets ".option scale=1.0u", so every
* instance L/W below is written in microns WITHOUT a "u" suffix.
.param mc_mm_switch=0
.param mc_pr_switch=0
.include /home/idies/workspace/Temporary/xyu1/scratch/skywater-pdk-libs-sky130_fd_pr/models/corners/tt.spice
.include /home/idies/workspace/Temporary/xyu1/scratch/skywater-pdk-libs-sky130_fd_pr/models/r+c/res_typical__cap_typical.spice
.include /home/idies/workspace/Temporary/xyu1/scratch/skywater-pdk-libs-sky130_fd_pr/models/r+c/res_typical__cap_typical__lin.spice
.include /home/idies/workspace/Temporary/xyu1/scratch/skywater-pdk-libs-sky130_fd_pr/models/corners/tt/specialized_cells.spice
.model DIDEAL D   is=1e-14 n=1
.options reltol=1e-3 itl1=500 itl2=100

* Sources
VVCTRL_N VCTRL_N 0 0.9
VVCTRL_P VCTRL_P 0 0.9
VVBAND_GAP VBAND_GAP 0 0.75

* Circuit
I9 VCC N11 1u
I10 VCC N5 1u
R11_1 N3 VCTRL_N 10k
R11_2 VCTRL_P N3 10k
R9_1 N6 GND 10k
I11 VCC N3 1u
XQ40 GND N5 N3 sky130_fd_pr__pnp_05v5_W3p40L3p40
R12 VCTRL_P VEXT 10k
XQ38 N4 N10 N12 0 sky130_fd_pr__npn_05v5_W1p00L1p00
R13_2 VCTRL_P N8 10k
R14 N8 GND 10k
R13_1 N8 VCTRL_N 10k
R9_2 N12 GND 10k
XQ36 N4 N1 N11 sky130_fd_pr__pnp_05v5_W3p40L3p40
R10 N5 N7 10k
R8 N1 VBAND_GAP 10k
XQ37 N10 N10 N6 0 sky130_fd_pr__npn_05v5_W1p00L1p00
C3 N4 N7 1p
XQ35 N10 N8 N11 sky130_fd_pr__pnp_05v5_W3p40L3p40
XQ39 N5 N4 GND 0 sky130_fd_pr__npn_05v5_W1p00L1p00

.control
set filetype=ascii

op
let power_dc = abs(i(VVCTRL_N)) * 1.8
print power_dc
let dc_voltage = v(N1)
print dc_voltage

quit
.endc

.end
