* Testcase 001173 — Full Analysis (sky130 tt corner)
* SKY130 model header — replaces the ideal level-1 .model cards
* Ships with the demo; the paths point at the local sky130 PDK checkout.
* NOTE: libs.tech/ngspice/all.spice sets ".option scale=1.0u", so every
* instance L/W below is written in microns WITHOUT a "u" suffix.
.param mc_mm_switch=0
.param mc_pr_switch=0
.include /home/idies/workspace/Temporary/xyu1/scratch/skywater-pdk-libs-sky130_fd_pr/models/corners/tt.spice
.include /home/idies/workspace/Temporary/xyu1/scratch/skywater-pdk-libs-sky130_fd_pr/models/r+c/res_typical__cap_typical.spice
.include /home/idies/workspace/Temporary/xyu1/scratch/skywater-pdk-libs-sky130_fd_pr/models/r+c/res_typical__cap_typical__lin.spice
.include /home/idies/workspace/Temporary/xyu1/scratch/skywater-pdk-libs-sky130_fd_pr/models/corners/tt/specialized_cells.spice
.model DIDEAL D   is=1e-14 n=1
.options reltol=1e-3 itl1=500 itl2=100

* Sources
VINP INP 0 DC 0.9 AC 1 SIN(0.9 0.1 1MEG 0 0)
VINN INN 0 DC 0.9 AC 1 SIN(0.9 0.1 1MEG 0 0)
VVB1 VB1 0 0.54
VVB2 VB2 0 0.54

* Circuit
R5 VCC N4 10k
R6 N9 N11 10k
R7 N9 N12 10k
R1 VCC N6 10k
XQ1 N3 INP N8 0 sky130_fd_pr__npn_05v5_W1p00L1p00
R2 N3 N6 10k
R3 N6 N7 10k
R4 VCC N5 10k
XQ6 N4 N1 N12 0 sky130_fd_pr__npn_05v5_W1p00L1p00
XQ2 N7 INN N8 0 sky130_fd_pr__npn_05v5_W1p00L1p00
XQ5 N5 N0 N11 0 sky130_fd_pr__npn_05v5_W1p00L1p00
XQ4 VCC N3 N1 0 sky130_fd_pr__npn_05v5_W1p00L1p00
XQ3 VCC N7 N0 0 sky130_fd_pr__npn_05v5_W1p00L1p00
XM1 N8 VB1 GND GND sky130_fd_pr__nfet_01v8 l=0.5 w=5
XM4 N9 N9 GND GND sky130_fd_pr__nfet_01v8 l=0.5 w=5
C1 VCC N6 1p
XM3 N1 N0 GND GND sky130_fd_pr__nfet_01v8 l=0.5 w=5
XM2 N0 VB2 GND GND sky130_fd_pr__nfet_01v8 l=0.5 w=5

.control
set filetype=ascii

op
let power_dc = abs(i(VINP)) * 1.8
print power_dc
let dc_voltage = v(N11)
print dc_voltage

quit
.endc

.end
