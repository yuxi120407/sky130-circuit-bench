* Testcase 000272 — Full Analysis (sky130 tt corner)
* SKY130 model header — replaces the ideal level-1 .model cards
* Ships with the demo; the paths point at the local sky130 PDK checkout.
* NOTE: libs.tech/ngspice/all.spice sets ".option scale=1.0u", so every
* instance L/W below is written in microns WITHOUT a "u" suffix.
.param mc_mm_switch=0
.param mc_pr_switch=0
.include /home/idies/workspace/Temporary/xyu1/scratch/skywater-pdk-libs-sky130_fd_pr/models/corners/tt.spice
.include /home/idies/workspace/Temporary/xyu1/scratch/skywater-pdk-libs-sky130_fd_pr/models/r+c/res_typical__cap_typical.spice
.include /home/idies/workspace/Temporary/xyu1/scratch/skywater-pdk-libs-sky130_fd_pr/models/r+c/res_typical__cap_typical__lin.spice
.include /home/idies/workspace/Temporary/xyu1/scratch/skywater-pdk-libs-sky130_fd_pr/models/corners/tt/specialized_cells.spice
.model DIDEAL D   is=1e-14 n=1
.options reltol=1e-3 itl1=500 itl2=100

* Sources
VIN IN 0 DC 0.9 AC 1 SIN(0.9 0.1 1MEG 0 0)
VINB INB 0 DC 0.9 AC 1 SIN(0.9 0.1 1MEG 0 0)

* Circuit
R1 N7 N13 10k
R2 N11 GND 10k
R3 N9 GND 10k
R4 N0 N7 10k
C1 N11 N13 1p
R5 N2 N6 10k
R7 N1 N6 10k
R6 N1 N4 10k
C2 N4 N15 1p
R8 N2 N3 10k
R9 IN N15 10k
R10 N4 N5 10k
C3 N13 GND 1p
R11 N8 INB 10k
C4 N5 GND 1p
C5 N14 GND 1p
R12 N0 N8 10k
R13 N13 N15 10k
R14 N3 N14 10k
C6 N0 GND 1p
C8 N3 N8 1p
C7 N0 N9 1p
C9 N11 IN 1p
C10 N9 INB 1p

.control
set filetype=ascii

op
let power_dc = abs(i(VIN)) * 1.8
print power_dc

ac dec 100 1 10g
let vout_mag = vm(N11)
let gain_db = db(vout_mag)

meas ac max_gain_db MAX gain_db
meas ac bw_3db WHEN gain_db='max_gain_db-3' CROSS=1

print max_gain_db bw_3db

quit
.endc

.end
