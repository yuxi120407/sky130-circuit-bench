* Testcase 000638 — Full Analysis (sky130 tt corner)
* SKY130 model header — replaces the ideal level-1 .model cards
* Ships with the demo; the paths point at the local sky130 PDK checkout.
* NOTE: libs.tech/ngspice/all.spice sets ".option scale=1.0u", so every
* instance L/W below is written in microns WITHOUT a "u" suffix.
.param mc_mm_switch=0
.param mc_pr_switch=0
.include /home/idies/workspace/Temporary/xyu1/scratch/skywater-pdk-libs-sky130_fd_pr/models/corners/tt.spice
.include /home/idies/workspace/Temporary/xyu1/scratch/skywater-pdk-libs-sky130_fd_pr/models/r+c/res_typical__cap_typical.spice
.include /home/idies/workspace/Temporary/xyu1/scratch/skywater-pdk-libs-sky130_fd_pr/models/r+c/res_typical__cap_typical__lin.spice
.include /home/idies/workspace/Temporary/xyu1/scratch/skywater-pdk-libs-sky130_fd_pr/models/corners/tt/specialized_cells.spice
.model DIDEAL D   is=1e-14 n=1
.options reltol=1e-3 itl1=500 itl2=100

* Sources
VVDD VDD 0 1.8
VIBUF IBUF 0 DC 0.75 AC 0.5

* Circuit
XQ1 N_E_LEFT IBUF N_Q1_E 0 sky130_fd_pr__npn_05v5_W1p00L1p00
XQ2 N_BIAS N_BIAS N_Q2_E 0 sky130_fd_pr__npn_05v5_W1p00L1p00
XQ3 N_Q7_E DINN N_E_RIGHT 0 sky130_fd_pr__npn_05v5_W1p00L1p00
XQ4 N_R2 N_Q7_B N_Q7_E 0 sky130_fd_pr__npn_05v5_W1p00L1p00
XQ5 VDD VDD N_BIAS 0 sky130_fd_pr__npn_05v5_W1p00L1p00
XQ6 IBUF IBUF N_Q6_E 0 sky130_fd_pr__npn_05v5_W1p00L1p00
XQ7 N_R2 N_Q7_B N_Q7_E 0 sky130_fd_pr__npn_05v5_W1p00L1p00
XQ8 N_E_RIGHT IBUF N_Q8_E 0 sky130_fd_pr__npn_05v5_W1p00L1p00
XQ9 N_E_LEFT IBUF N_Q9_E 0 sky130_fd_pr__npn_05v5_W1p00L1p00
XQ10 N_R4 N_Q15_B N_Q15_E 0 sky130_fd_pr__npn_05v5_W1p00L1p00
XQ11 N_Q15_E DINP N_E_LEFT 0 sky130_fd_pr__npn_05v5_W1p00L1p00
XQ12 N_Q7_E DINN N_E_RIGHT 0 sky130_fd_pr__npn_05v5_W1p00L1p00
XQ13 N_E_RIGHT IBUF N_Q13_E 0 sky130_fd_pr__npn_05v5_W1p00L1p00
XQ14 N_Q15_E DINP N_E_LEFT 0 sky130_fd_pr__npn_05v5_W1p00L1p00
XQ15 N_R4 N_Q15_B N_Q15_E 0 sky130_fd_pr__npn_05v5_W1p00L1p00
XQ16 N_Q16_C IBUF N_Q16_E 0 sky130_fd_pr__npn_05v5_W1p00L1p00
R1 N_Q8_E GND 30
R2 VDD N_R2 55
R3 N_Q6_E GND 30
R4 VDD N_R4 55
R5 N_Q13_E GND 30
R6 N_Q9_E GND 30
R7 N_Q1_E GND 30
R8 N_BIAS N_Q7_B 5
R9 N_Q16_E GND 30
R10 N_Q2_E N_Q16_C 90
R11 N_BIAS N_Q15_B 5
R12 N_R4 OUTN 5
R13 N_R2 OUTP 5
R14 N_E_LEFT N_MID 10
R15 N_MID N_E_RIGHT 10
C1 N_BIAS GND 1.1p

.control
set filetype=ascii

op
let vdd_current = abs(i(VVDD))
let power_dc = vdd_current * 1.8
print power_dc

ac dec 100 1 10g
let vout_mag = vm(OUTP)
let gain_db = db(vout_mag)
let dc_gain_db = gain_db[0]
print dc_gain_db

if dc_gain_db > 0
    meas ac ugbw WHEN gain_db=0 CROSS=1
end

quit
.endc

.end
