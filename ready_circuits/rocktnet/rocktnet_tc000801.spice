* Testcase 000801 — Full Analysis (sky130 tt corner)
* SKY130 model header — replaces the ideal level-1 .model cards
* Ships with the demo; the paths point at the local sky130 PDK checkout.
* NOTE: libs.tech/ngspice/all.spice sets ".option scale=1.0u", so every
* instance L/W below is written in microns WITHOUT a "u" suffix.
.param mc_mm_switch=0
.param mc_pr_switch=0
.include /home/idies/workspace/Temporary/xyu1/scratch/skywater-pdk-libs-sky130_fd_pr/models/corners/tt.spice
.include /home/idies/workspace/Temporary/xyu1/scratch/skywater-pdk-libs-sky130_fd_pr/models/r+c/res_typical__cap_typical.spice
.include /home/idies/workspace/Temporary/xyu1/scratch/skywater-pdk-libs-sky130_fd_pr/models/r+c/res_typical__cap_typical__lin.spice
.include /home/idies/workspace/Temporary/xyu1/scratch/skywater-pdk-libs-sky130_fd_pr/models/corners/tt/specialized_cells.spice
.model DIDEAL D   is=1e-14 n=1
.options reltol=1e-3 itl1=500 itl2=100

* Sources
VVBLON VBLON 0 DC 0.75 AC 0.5
VVBLOP VBLOP 0 0.75

* Circuit
XM2_N IF_N LOCN N2 GND sky130_fd_pr__nfet_01v8 l=0.5 w=5
XM1_N IF_P LON N2 GND sky130_fd_pr__nfet_01v8 l=0.5 w=5
R1 VBLON LOCN 10k
R2 VBLON LON 10k
R3 N1 VBLOP 10k
R4 N0 VBLOP 10k
XM1_P IF_P N1 N2 GND sky130_fd_pr__nfet_01v8 l=0.5 w=5
XM2_P IF_N N0 N2 GND sky130_fd_pr__nfet_01v8 l=0.5 w=5
C1 LOCN LOC 1p
C2 N0 LO 1p
C3 LON LO 1p
C4 N2 RF 1p
C5 N1 LOC 1p

.control
set filetype=ascii

op
let power_dc = abs(i(VVBLON)) * 1.8
print power_dc
let dc_voltage = v(LO)
print dc_voltage

quit
.endc

.end
