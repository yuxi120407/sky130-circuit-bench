* Testcase 001045 — Full Analysis (sky130 tt corner)
* SKY130 model header — replaces the ideal level-1 .model cards
* Ships with the demo; the paths point at the local sky130 PDK checkout.
* NOTE: libs.tech/ngspice/all.spice sets ".option scale=1.0u", so every
* instance L/W below is written in microns WITHOUT a "u" suffix.
.param mc_mm_switch=0
.param mc_pr_switch=0
.include /home/idies/workspace/Temporary/xyu1/scratch/skywater-pdk-libs-sky130_fd_pr/models/corners/tt.spice
.include /home/idies/workspace/Temporary/xyu1/scratch/skywater-pdk-libs-sky130_fd_pr/models/r+c/res_typical__cap_typical.spice
.include /home/idies/workspace/Temporary/xyu1/scratch/skywater-pdk-libs-sky130_fd_pr/models/r+c/res_typical__cap_typical__lin.spice
.include /home/idies/workspace/Temporary/xyu1/scratch/skywater-pdk-libs-sky130_fd_pr/models/corners/tt/specialized_cells.spice
.model DIDEAL D   is=1e-14 n=1
.options reltol=1e-3 itl1=500 itl2=100

* Sources
VLABEL_NET_0 LABEL_NET_0 0 DC 0.9 AC 0.5
VLABEL_NET_1 LABEL_NET_1 0 DC 0.9 AC -0.5
VLABEL_NET_2 LABEL_NET_2 0 0.9

* Circuit
C1 ANT N3 1p
C2 N0 ANT 1p
C3 N4 TX_AND_DRAIN_DC_BIAS 1p
R1 N0 GND 10k
R2 N3 GND 10k
C4 RX_AND_DRAIN_DC_BIAS N3 1p
C5 N0 TX_AND_DRAIN_DC_BIAS 1p
XM1 ANT LABEL_NET_0 TX_AND_DRAIN_DC_BIAS GND sky130_fd_pr__nfet_01v8 l=0.5 w=5
R3 N7 GND 10k
R4 N4 GND 10k
XM2 LABEL_NET_1 ANT RX_AND_DRAIN_DC_BIAS GND sky130_fd_pr__nfet_01v8 l=0.5 w=5
XM3 TX_AND_DRAIN_DC_BIAS LABEL_NET_2 TX_SOURCE_DC_BIAS GND sky130_fd_pr__nfet_01v8 l=0.5 w=5
C6 RX_AND_DRAIN_DC_BIAS N7 1p
C7 N4 TX_SOURCE_DC_BIAS 1p
C8 RX_AND_DRAIN_DC_BIAS N7 1p

.control
set filetype=ascii

op
let vdd_current = abs(i(VVDD))
let power_dc = vdd_current * 1.8
print power_dc

ac dec 100 1 10g
let vout_mag = vm(N0)
let gain_db = db(vout_mag)
let dc_gain_db = gain_db[0]
print dc_gain_db

if dc_gain_db > 0
    meas ac ugbw WHEN gain_db=0 CROSS=1
end

quit
.endc

.end
