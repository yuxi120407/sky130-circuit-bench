* Testcase 000520 — Full Analysis (sky130 tt corner)
* SKY130 model header — replaces the ideal level-1 .model cards
* Ships with the demo; the paths point at the local sky130 PDK checkout.
* NOTE: libs.tech/ngspice/all.spice sets ".option scale=1.0u", so every
* instance L/W below is written in microns WITHOUT a "u" suffix.
.param mc_mm_switch=0
.param mc_pr_switch=0
.include /home/idies/workspace/Temporary/xyu1/scratch/skywater-pdk-libs-sky130_fd_pr/models/corners/tt.spice
.include /home/idies/workspace/Temporary/xyu1/scratch/skywater-pdk-libs-sky130_fd_pr/models/r+c/res_typical__cap_typical.spice
.include /home/idies/workspace/Temporary/xyu1/scratch/skywater-pdk-libs-sky130_fd_pr/models/r+c/res_typical__cap_typical__lin.spice
.include /home/idies/workspace/Temporary/xyu1/scratch/skywater-pdk-libs-sky130_fd_pr/models/corners/tt/specialized_cells.spice
.model DIDEAL D   is=1e-14 n=1
.options reltol=1e-3 itl1=500 itl2=100

* Sources
VVDD VDD 0 1.8
VVREF VREF 0 0.9

* Circuit
XM16 VDD VREF A GND sky130_fd_pr__nfet_01v8 l=0.5 w=5
XM9 A A X GND sky130_fd_pr__nfet_01v8 l=0.5 w=5
XM15 X A X GND sky130_fd_pr__nfet_01v8 l=0.5 w=5
XM5 X VGM GND GND sky130_fd_pr__nfet_01v8 l=0.5 w=5
XM14 N_LS1 VP VDD VDD sky130_fd_pr__pfet_01v8 l=0.5 w=5
XM10 Y X N_LS1 VDD sky130_fd_pr__pfet_01v8 l=0.5 w=5
XM12 VDD N_LS1 Y GND sky130_fd_pr__nfet_01v8 l=0.5 w=5
XM11 Y VGM GND GND sky130_fd_pr__nfet_01v8 l=0.5 w=5
XMP AP Y VDD VDD sky130_fd_pr__pfet_01v8 l=0.5 w=5
XM13 AP VREF N_MG1 GND sky130_fd_pr__nfet_01v8 l=0.5 w=5
XM17 N_MG1 AP N_MG1 GND sky130_fd_pr__nfet_01v8 l=0.5 w=5
XM2 N_MG1 VGM GND GND sky130_fd_pr__nfet_01v8 l=0.5 w=5
XM8 GND AP GND GND sky130_fd_pr__nfet_01v8 l=0.5 w=5
XM18 VP VP VDD VDD sky130_fd_pr__pfet_01v8 l=0.5 w=5
XM19 N_EA2 VP VDD VDD sky130_fd_pr__pfet_01v8 l=0.5 w=5
XM7 VP AP N_EA3 GND sky130_fd_pr__nfet_01v8 l=0.5 w=5
XM3 N_EA2 VREF N_EA3 GND sky130_fd_pr__nfet_01v8 l=0.5 w=5
XM4 N_EA3 VGM GND GND sky130_fd_pr__nfet_01v8 l=0.5 w=5

.control
set filetype=ascii

op
let vdd_current = abs(i(VVDD))
let power_dc = vdd_current * 1.8
print power_dc

print all

quit
.endc

.end
