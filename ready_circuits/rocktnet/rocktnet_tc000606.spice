* Testcase 000606 — Full Analysis (sky130 tt corner)
* SKY130 model header — replaces the ideal level-1 .model cards
* Ships with the demo; the paths point at the local sky130 PDK checkout.
* NOTE: libs.tech/ngspice/all.spice sets ".option scale=1.0u", so every
* instance L/W below is written in microns WITHOUT a "u" suffix.
.param mc_mm_switch=0
.param mc_pr_switch=0
.include /home/idies/workspace/Temporary/xyu1/scratch/skywater-pdk-libs-sky130_fd_pr/models/corners/tt.spice
.include /home/idies/workspace/Temporary/xyu1/scratch/skywater-pdk-libs-sky130_fd_pr/models/r+c/res_typical__cap_typical.spice
.include /home/idies/workspace/Temporary/xyu1/scratch/skywater-pdk-libs-sky130_fd_pr/models/r+c/res_typical__cap_typical__lin.spice
.include /home/idies/workspace/Temporary/xyu1/scratch/skywater-pdk-libs-sky130_fd_pr/models/corners/tt/specialized_cells.spice
.model DIDEAL D   is=1e-14 n=1
.options reltol=1e-3 itl1=500 itl2=100

* Sources
VVDD VDD 0 1.8
VIN1 IN1 0 DC 0.9 AC 1 SIN(0.9 0.1 1MEG 0 0)
VIN2 IN2 0 DC 0.9 AC 1 SIN(0.9 0.1 1MEG 0 0)
VLABEL_NET_1 LABEL_NET_1 0 DC 0.9 AC 1

* Circuit
XMI2 N5 R_P GND GND sky130_fd_pr__nfet_01v8 l=0.5 w=5
XM13 N13 N13 GND GND sky130_fd_pr__nfet_01v8 l=0.5 w=5
XM3 N11 N11 GND GND sky130_fd_pr__nfet_01v8 l=0.5 w=5
XM18 N7 N16 VDD VDD sky130_fd_pr__pfet_01v8 l=0.5 w=5
XM10 OUT_P N0 GND GND sky130_fd_pr__nfet_01v8 l=0.5 w=5
XM5 N3 OUT_P IN1 VDD sky130_fd_pr__pfet_01v8 l=0.5 w=5
XM8 N0 N3 GND GND sky130_fd_pr__nfet_01v8 l=0.5 w=5
XM6 N0 IN1 IN1 VDD sky130_fd_pr__pfet_01v8 l=0.5 w=5
XM15 N16 OUT_N N1 GND sky130_fd_pr__nfet_01v8 l=0.5 w=5
XM17 N16 N16 VDD VDD sky130_fd_pr__pfet_01v8 l=0.5 w=5
XM1 N6 N6 VDD VDD sky130_fd_pr__pfet_01v8 l=0.5 w=5
XM19 OUT_N N7 VDD VDD sky130_fd_pr__pfet_01v8 l=0.5 w=5
XM7 N3 N3 GND GND sky130_fd_pr__nfet_01v8 l=0.5 w=5
XM16 N7 IN2 N1 GND sky130_fd_pr__nfet_01v8 l=0.5 w=5
XM20 OUT_N N14 GND GND sky130_fd_pr__nfet_01v8 l=0.5 w=5
XMTG1_1 OUT_P R_P OUT1 GND sky130_fd_pr__nfet_01v8 l=0.5 w=5
XMDUMMY VDD VDD VDD VDD sky130_fd_pr__pfet_01v8 l=0.5 w=5
XM4 IN1 N6 VDD VDD sky130_fd_pr__pfet_01v8 l=0.5 w=5
XMI1 N5 R_P VDD VDD sky130_fd_pr__pfet_01v8 l=0.5 w=5
XM9 OUT_P N6 VDD VDD sky130_fd_pr__pfet_01v8 l=0.5 w=5
XM21 OUT_P N5 OUT1 GND sky130_fd_pr__nfet_01v8 l=0.5 w=5
XM12 N13 N13 N15 VDD sky130_fd_pr__pfet_01v8 l=0.5 w=5
XM23 OUT_P N5 OUT1 GND sky130_fd_pr__nfet_01v8 l=0.5 w=5
XM24 OUT_N R_P OUT1 GND sky130_fd_pr__nfet_01v8 l=0.5 w=5
XM2 N6 N6 N11 GND sky130_fd_pr__nfet_01v8 l=0.5 w=5
XM26 OUT_N N5 OUT1 GND sky130_fd_pr__nfet_01v8 l=0.5 w=5
XM27 OUT_P R_P OUT1 GND sky130_fd_pr__nfet_01v8 l=0.5 w=5
XM28 N5 N5 OUT1 GND sky130_fd_pr__nfet_01v8 l=0.5 w=5
XM14 N1 N13 N14 GND sky130_fd_pr__nfet_01v8 l=0.5 w=5
XM11 N15 LABEL_NET_1 VDD VDD sky130_fd_pr__pfet_01v8 l=0.5 w=5
XM31 OUT_N R_P OUT1 GND sky130_fd_pr__nfet_01v8 l=0.5 w=5

.control
set filetype=ascii

op
let power_dc = abs(i(VVDD)) * 1.8
print power_dc

ac dec 100 1 10g
let gain_N5 = db(vm(N5))
let gain_R_P = db(vm(R_P))
let gain_N6 = db(vm(N6))
let gain_N15 = db(vm(N15))
let gain_OUT_P = db(vm(OUT_P))
meas ac max_gain_N5 MAX gain_N5
meas ac max_gain_R_P MAX gain_R_P
meas ac max_gain_N6 MAX gain_N6
meas ac max_gain_N15 MAX gain_N15
meas ac max_gain_OUT_P MAX gain_OUT_P

* Use first probe node for standard metrics
let gain_db = db(vm(N5))
meas ac dc_gain_db FIND gain_db AT=1
meas ac ugbw WHEN gain_db=0 CROSS=1
let vout_dc = v(N5)

print dc_gain_db ugbw vout_dc gain_N5 gain_R_P gain_N6 gain_N15 gain_OUT_P

quit
.endc

.end
