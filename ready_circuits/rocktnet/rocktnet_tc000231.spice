* Testcase 000231 — Full Analysis (sky130 tt corner)
* SKY130 model header — replaces the ideal level-1 .model cards
* Ships with the demo; the paths point at the local sky130 PDK checkout.
* NOTE: libs.tech/ngspice/all.spice sets ".option scale=1.0u", so every
* instance L/W below is written in microns WITHOUT a "u" suffix.
.param mc_mm_switch=0
.param mc_pr_switch=0
.include /home/idies/workspace/Temporary/xyu1/scratch/skywater-pdk-libs-sky130_fd_pr/models/corners/tt.spice
.include /home/idies/workspace/Temporary/xyu1/scratch/skywater-pdk-libs-sky130_fd_pr/models/r+c/res_typical__cap_typical.spice
.include /home/idies/workspace/Temporary/xyu1/scratch/skywater-pdk-libs-sky130_fd_pr/models/r+c/res_typical__cap_typical__lin.spice
.include /home/idies/workspace/Temporary/xyu1/scratch/skywater-pdk-libs-sky130_fd_pr/models/corners/tt/specialized_cells.spice
.model DIDEAL D   is=1e-14 n=1
.options reltol=1e-3 itl1=500 itl2=100

* Sources
VVDD VDD 0 1.8
VVIN VIN 0 DC 0.9 AC 1 SIN(0.9 0.1 1MEG 0 0)
VVB3 VB3 0 0.54
VVB2 VB2 0 0.9900000000000001
VVB1 VB1 0 0.9900000000000001
VVB5 VB5 0 0.54
VVCMFB VCMFB 0 0.9

* Circuit
XM1 VDD VIP N3 GND sky130_fd_pr__nfet_01v8 l=0.5 w=5
XM2 VDD VIN N4 GND sky130_fd_pr__nfet_01v8 l=0.5 w=5
XM3 N5 N3 N7 GND sky130_fd_pr__nfet_01v8 l=0.5 w=5
XM4 N6 N4 N7 GND sky130_fd_pr__nfet_01v8 l=0.5 w=5
XM5 VON VB3 N5 GND sky130_fd_pr__nfet_01v8 l=0.5 w=5
XM6 VOP VB3 N6 GND sky130_fd_pr__nfet_01v8 l=0.5 w=5
XM7 VON VB2 N1 VDD sky130_fd_pr__pfet_01v8 l=0.5 w=5
XM8 VOP VB2 N2 VDD sky130_fd_pr__pfet_01v8 l=0.5 w=5
XM9 N1 VB1 VDD VDD sky130_fd_pr__pfet_01v8 l=0.5 w=5
XM10 N2 VB1 VDD VDD sky130_fd_pr__pfet_01v8 l=0.5 w=5
XM11 N3 VB5 GND GND sky130_fd_pr__nfet_01v8 l=0.5 w=5
XM12 N7 VB5 GND GND sky130_fd_pr__nfet_01v8 l=0.5 w=5
XM13 N7 VCMFB GND GND sky130_fd_pr__nfet_01v8 l=0.5 w=5
XM14 N4 VB5 GND GND sky130_fd_pr__nfet_01v8 l=0.5 w=5

.control
set filetype=ascii

op
let power_dc = abs(i(VVDD)) * 1.8
print power_dc

ac dec 100 1 10g
let vout_mag = vm(N4)
let gain_db = db(vout_mag)
let dc_gain_db = gain_db[0]
print dc_gain_db

if dc_gain_db > 0
    meas ac ugbw WHEN gain_db=0 CROSS=1
    print ugbw
end

quit
.endc

.end
