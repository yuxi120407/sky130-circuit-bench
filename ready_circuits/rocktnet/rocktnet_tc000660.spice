* Testcase 000660 — Full Analysis (sky130 tt corner)
* SKY130 model header — replaces the ideal level-1 .model cards
* Ships with the demo; the paths point at the local sky130 PDK checkout.
* NOTE: libs.tech/ngspice/all.spice sets ".option scale=1.0u", so every
* instance L/W below is written in microns WITHOUT a "u" suffix.
.param mc_mm_switch=0
.param mc_pr_switch=0
.include /home/idies/workspace/Temporary/xyu1/scratch/skywater-pdk-libs-sky130_fd_pr/models/corners/tt.spice
.include /home/idies/workspace/Temporary/xyu1/scratch/skywater-pdk-libs-sky130_fd_pr/models/r+c/res_typical__cap_typical.spice
.include /home/idies/workspace/Temporary/xyu1/scratch/skywater-pdk-libs-sky130_fd_pr/models/r+c/res_typical__cap_typical__lin.spice
.include /home/idies/workspace/Temporary/xyu1/scratch/skywater-pdk-libs-sky130_fd_pr/models/corners/tt/specialized_cells.spice
.model DIDEAL D   is=1e-14 n=1
.options reltol=1e-3 itl1=500 itl2=100

* Sources
VVDD VDD 0 1.8
VLABEL_NET_0 LABEL_NET_0 0 DC 0.9 AC 0.5
VLABEL_NET_1 LABEL_NET_1 0 DC 0.9 AC -0.5
VLABEL_NET_2 LABEL_NET_2 0 0.9
VLABEL_NET_3 LABEL_NET_3 0 0.9

* Circuit
I1 VDD N9 1u
I2 VDD N7 1u
XM1 N7 N4 VDD VDD sky130_fd_pr__pfet_01v8 l=0.5 w=5
XM2 N4 N20 GND GND sky130_fd_pr__nfet_01v8 l=0.5 w=5
XM3 N13 N20 GND GND sky130_fd_pr__nfet_01v8 l=0.5 w=5
XM4 N17 N22 GND GND sky130_fd_pr__nfet_01v8 l=0.5 w=5
XM5 N12 N15 N9 VDD sky130_fd_pr__pfet_01v8 l=0.5 w=5
XM6 N6 N23 GND GND sky130_fd_pr__nfet_01v8 l=0.5 w=5
XM7 N18 LABEL_NET_0 GND GND sky130_fd_pr__nfet_01v8 l=0.5 w=5
XM8 N16 LABEL_NET_1 GND GND sky130_fd_pr__nfet_01v8 l=0.5 w=5
XM9 N5 N11 N8 VDD sky130_fd_pr__pfet_01v8 l=0.5 w=5
XM10 N4 N11 N7 VDD sky130_fd_pr__pfet_01v8 l=0.5 w=5
XM11 N23 N15 N2 VDD sky130_fd_pr__pfet_01v8 l=0.5 w=5
XM12 N0 LABEL_NET_2 N17 GND sky130_fd_pr__nfet_01v8 l=0.5 w=5
XM13 N9 N12 VDD VDD sky130_fd_pr__pfet_01v8 l=0.5 w=5
XM14 N18 N18 N0 VDD sky130_fd_pr__pfet_01v8 l=0.5 w=5
XM15 N0 N18 VDD VDD sky130_fd_pr__pfet_01v8 l=0.5 w=5
XM16 N16 LABEL_NET_3 N3 VDD sky130_fd_pr__pfet_01v8 l=0.5 w=5
XM17 N12 N19 GND GND sky130_fd_pr__nfet_01v8 l=0.5 w=5
XM18 N9 N17 N17 GND sky130_fd_pr__nfet_01v8 l=0.5 w=5
XM19 N2 N12 VDD VDD sky130_fd_pr__pfet_01v8 l=0.5 w=5
XM20 N8 N4 VDD VDD sky130_fd_pr__pfet_01v8 l=0.5 w=5
XM21 N1 N23 GND GND sky130_fd_pr__nfet_01v8 l=0.5 w=5
XM22 N23 N14 N1 GND sky130_fd_pr__nfet_01v8 l=0.5 w=5
XM23 N3 N16 VDD VDD sky130_fd_pr__pfet_01v8 l=0.5 w=5
XM24 N7 N7 N13 GND sky130_fd_pr__nfet_01v8 l=0.5 w=5
XM25 N5 N14 N6 GND sky130_fd_pr__nfet_01v8 l=0.5 w=5
XM26 N3 N13 N13 GND sky130_fd_pr__nfet_01v8 l=0.5 w=5
C1 N9 N12 1p
C2 N0 N18 1p
C3 N4 N7 1p
C4 N3 N16 1p

.control
set filetype=ascii

op
let power_dc = abs(i(VVDD)) * 1.8
print power_dc

ac dec 100 1 10g
let vout_mag = vm(N0)
let gain_db = db(vout_mag)
let dc_gain_db = gain_db[0]
print dc_gain_db

if dc_gain_db > 0
    meas ac ugbw WHEN gain_db=0 CROSS=1
    print ugbw
end

quit
.endc

.end
