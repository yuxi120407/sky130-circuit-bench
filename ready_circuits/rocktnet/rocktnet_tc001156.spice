* Testcase 001156 — Full Analysis (sky130 tt corner)
* SKY130 model header — replaces the ideal level-1 .model cards
* Ships with the demo; the paths point at the local sky130 PDK checkout.
* NOTE: libs.tech/ngspice/all.spice sets ".option scale=1.0u", so every
* instance L/W below is written in microns WITHOUT a "u" suffix.
.param mc_mm_switch=0
.param mc_pr_switch=0
.include /home/idies/workspace/Temporary/xyu1/scratch/skywater-pdk-libs-sky130_fd_pr/models/corners/tt.spice
.include /home/idies/workspace/Temporary/xyu1/scratch/skywater-pdk-libs-sky130_fd_pr/models/r+c/res_typical__cap_typical.spice
.include /home/idies/workspace/Temporary/xyu1/scratch/skywater-pdk-libs-sky130_fd_pr/models/r+c/res_typical__cap_typical__lin.spice
.include /home/idies/workspace/Temporary/xyu1/scratch/skywater-pdk-libs-sky130_fd_pr/models/corners/tt/specialized_cells.spice
.model DIDEAL D   is=1e-14 n=1
.options reltol=1e-3 itl1=500 itl2=100

* Sources
VVDD VDD 0 1.8
VLABEL_NET_0 LABEL_NET_0 0 0.9
VVB4 VB4 0 0.9900000000000001
VLABEL_NET_1 LABEL_NET_1 0 0.9
VLABEL_NET_3 LABEL_NET_3 0 0.9
VVB2 VB2 0 0.54
VVIN_MINUS VIN_MINUS 0 DC 0.9 AC 1 SIN(0.9 0.1 1MEG 0 0)
VVIN_PLUS VIN_PLUS 0 DC 0.9 AC 1 SIN(0.9 0.1 1MEG 0 0)

* Circuit
I1 LABEL_NET_0 CM_REF 1u
XM1 N4 VB4 LABEL_NET_1 VDD sky130_fd_pr__pfet_01v8 l=0.5 w=5
XM2 N3 VB4 LABEL_NET_3 VDD sky130_fd_pr__pfet_01v8 l=0.5 w=5
XM3 VO_MINUS VO_MINUS N4 VDD sky130_fd_pr__pfet_01v8 l=0.5 w=5
XM4 CM_REF CM_REF GND GND sky130_fd_pr__nfet_01v8 l=0.5 w=5
XM5 VO_PLUS N3 N3 VDD sky130_fd_pr__pfet_01v8 l=0.5 w=5
XM6 VO_MINUS N6 N6 GND sky130_fd_pr__nfet_01v8 l=0.5 w=5
XM7 VO_PLUS VB2 N8 GND sky130_fd_pr__nfet_01v8 l=0.5 w=5
XM8 N2 CMFB GND GND sky130_fd_pr__nfet_01v8 l=0.5 w=5
XM9 N8 VIN_MINUS N2 GND sky130_fd_pr__nfet_01v8 l=0.5 w=5
C1 VO_PLUS CMFB 1p
C2 VO_PLUS VO_PLUS 1p
C3 VO_MINUS CMFB 1p
XM10 N6 VIN_PLUS N2 GND sky130_fd_pr__nfet_01v8 l=0.5 w=5
C4 CMFB CMFB 1p

.control
set filetype=ascii

op
let power_dc = abs(i(VVDD)) * 1.8
print power_dc

ac dec 100 1 10g
let vout_mag = vm(N2)
let gain_db = db(vout_mag)
let dc_gain_db = gain_db[0]
print dc_gain_db

if dc_gain_db > 0
    meas ac ugbw WHEN gain_db=0 CROSS=1
    print ugbw
end

quit
.endc

.end
