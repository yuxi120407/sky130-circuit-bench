* Testcase 000297 — Full Analysis (sky130 tt corner)
* SKY130 model header — replaces the ideal level-1 .model cards
* Ships with the demo; the paths point at the local sky130 PDK checkout.
* NOTE: libs.tech/ngspice/all.spice sets ".option scale=1.0u", so every
* instance L/W below is written in microns WITHOUT a "u" suffix.
.param mc_mm_switch=0
.param mc_pr_switch=0
.include /home/idies/workspace/Temporary/xyu1/scratch/skywater-pdk-libs-sky130_fd_pr/models/corners/tt.spice
.include /home/idies/workspace/Temporary/xyu1/scratch/skywater-pdk-libs-sky130_fd_pr/models/r+c/res_typical__cap_typical.spice
.include /home/idies/workspace/Temporary/xyu1/scratch/skywater-pdk-libs-sky130_fd_pr/models/r+c/res_typical__cap_typical__lin.spice
.include /home/idies/workspace/Temporary/xyu1/scratch/skywater-pdk-libs-sky130_fd_pr/models/corners/tt/specialized_cells.spice
.model DIDEAL D   is=1e-14 n=1
.options reltol=1e-3 itl1=500 itl2=100

* Sources
VVDD VDD 0 1.8
VVIN VIN 0 DC 0.9 AC 1 SIN(0.9 0.1 1MEG 0 0)
VVB1 VB1 0 0.54
VVB2 VB2 0 0.75

* Circuit
LI2 N11 N12 10n
LI1 N8 N11 10n
XM3 N4 N5 N8 GND sky130_fd_pr__nfet_01v8 l=0.5 w=5
LP N6 N11 10n
XM1 N13 VIN N9 GND sky130_fd_pr__nfet_01v8 l=0.5 w=5
LS N9 GND 10n
XM7 VIF_P VLO_N N1 GND sky130_fd_pr__nfet_01v8 l=0.5 w=5
L5 VDD VIF_P 10n
XM2 N6 VB1 N13 GND sky130_fd_pr__nfet_01v8 l=0.5 w=5
XM4 N1 N2 N12 GND sky130_fd_pr__nfet_01v8 l=0.5 w=5
XM5 VIF_P VLO_P N4 GND sky130_fd_pr__nfet_01v8 l=0.5 w=5
XM6 VIF_N VLO_N N4 GND sky130_fd_pr__nfet_01v8 l=0.5 w=5
L6 VDD VIF_N 10n
R1 N5 VB2 10k
XM8 VIF_N VLO_P N1 GND sky130_fd_pr__nfet_01v8 l=0.5 w=5
R2 N2 VB2 10k
CI1 N8 N11 1p
CC N5 N6 1p
CB1 N11 GND 1p
CB2 N2 GND 1p
CP N6 N11 1p
CI2 N11 N12 1p

.control
set filetype=ascii

op
let vdd_current = abs(i(VVDD))
let power_dc = vdd_current * 1.8
print power_dc

ac dec 100 1k 100g
let vout_mag = vm(N11)
let gain_db = db(vout_mag)

meas ac max_gain_db MAX gain_db
meas ac bw_3db WHEN gain_db='max_gain_db-3' CROSS=1

print max_gain_db bw_3db

quit
.endc

.end
