* Testcase 001198 — Full Analysis (sky130 tt corner)
* SKY130 model header — replaces the ideal level-1 .model cards
* Ships with the demo; the paths point at the local sky130 PDK checkout.
* NOTE: libs.tech/ngspice/all.spice sets ".option scale=1.0u", so every
* instance L/W below is written in microns WITHOUT a "u" suffix.
.param mc_mm_switch=0
.param mc_pr_switch=0
.include /home/idies/workspace/Temporary/xyu1/scratch/skywater-pdk-libs-sky130_fd_pr/models/corners/tt.spice
.include /home/idies/workspace/Temporary/xyu1/scratch/skywater-pdk-libs-sky130_fd_pr/models/r+c/res_typical__cap_typical.spice
.include /home/idies/workspace/Temporary/xyu1/scratch/skywater-pdk-libs-sky130_fd_pr/models/r+c/res_typical__cap_typical__lin.spice
.include /home/idies/workspace/Temporary/xyu1/scratch/skywater-pdk-libs-sky130_fd_pr/models/corners/tt/specialized_cells.spice
.model DIDEAL D   is=1e-14 n=1
.options reltol=1e-2 abstol=1e-10 vntol=1e-4 itl1=1000 itl2=200 itl4=100
.options gmin=1e-10 method=gear

* Sources

* Circuit
I1 N7 VEE 1u
I2 N5 VEE 1u
R1 N0 GND 10k
R2 N0 GND 10k
R3 VOUT GND 10k
R4 N1 GND 10k
XQ1 N0 DATA_IN N6 0 sky130_fd_pr__npn_05v5_W1p00L1p00
XQ2 N0 N0 N10 0 sky130_fd_pr__npn_05v5_W1p00L1p00
XQ3 N1 N0 N0 0 sky130_fd_pr__npn_05v5_W1p00L1p00
XQ4 VOUT N0 N0 0 sky130_fd_pr__npn_05v5_W1p00L1p00
XQ5 N0 N5 N7 0 sky130_fd_pr__npn_05v5_W1p00L1p00
XQ6 N0 N6 N6 0 sky130_fd_pr__npn_05v5_W1p00L1p00
XQ7 N0 N0 N10 0 sky130_fd_pr__npn_05v5_W1p00L1p00
XQ8 VOUT N1 N9 0 sky130_fd_pr__npn_05v5_W1p00L1p00
XQ9 N6 CLK_IN N5 0 sky130_fd_pr__npn_05v5_W1p00L1p00
XQ10 N1 VOUT N9 0 sky130_fd_pr__npn_05v5_W1p00L1p00
XQ11 N9 CLK_IN N7 0 sky130_fd_pr__npn_05v5_W1p00L1p00
XQ12 N5 N5 N10 sky130_fd_pr__pnp_05v5_W3p40L3p40

.control
set filetype=ascii

op

let dc_voltage = v(VOUT)
print dc_voltage
print all

quit
.endc

.end
