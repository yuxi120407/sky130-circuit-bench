* Testcase 000772 — Full Analysis (sky130 tt corner)
* SKY130 model header — replaces the ideal level-1 .model cards
* Ships with the demo; the paths point at the local sky130 PDK checkout.
* NOTE: libs.tech/ngspice/all.spice sets ".option scale=1.0u", so every
* instance L/W below is written in microns WITHOUT a "u" suffix.
.param mc_mm_switch=0
.param mc_pr_switch=0
.include /home/idies/workspace/Temporary/xyu1/scratch/skywater-pdk-libs-sky130_fd_pr/models/corners/tt.spice
.include /home/idies/workspace/Temporary/xyu1/scratch/skywater-pdk-libs-sky130_fd_pr/models/r+c/res_typical__cap_typical.spice
.include /home/idies/workspace/Temporary/xyu1/scratch/skywater-pdk-libs-sky130_fd_pr/models/r+c/res_typical__cap_typical__lin.spice
.include /home/idies/workspace/Temporary/xyu1/scratch/skywater-pdk-libs-sky130_fd_pr/models/corners/tt/specialized_cells.spice
.model DIDEAL D   is=1e-14 n=1
.options reltol=1e-3 itl1=500 itl2=100

* Sources
VLABEL_NET_0 LABEL_NET_0 0 DC 0.9 AC 0.5
VLABEL_NET_1 LABEL_NET_1 0 DC 0.9 AC -0.5
VLABEL_NET_2 LABEL_NET_2 0 0.9
VLABEL_NET_3 LABEL_NET_3 0 0.9

* Circuit
C1 N9 N10 1p
R1 N8 N9 10k
C2 N7 LABEL_NET_0 1p
XM1 N11 N2 N1 GND sky130_fd_pr__nfet_01v8 l=0.5 w=5
XM2 N6 N4 GND GND sky130_fd_pr__nfet_01v8 l=0.5 w=5
C3 N4 N11 1p
XM3 N10 N2 N3 GND sky130_fd_pr__nfet_01v8 l=0.5 w=5
XM4 N7 N9 GND GND sky130_fd_pr__nfet_01v8 l=0.5 w=5
XM5 N3 LABEL_NET_1 GND GND sky130_fd_pr__nfet_01v8 l=0.5 w=5
C4 N6 LABEL_NET_2 1p
XM6 N1 LABEL_NET_3 GND GND sky130_fd_pr__nfet_01v8 l=0.5 w=5
R2 N4 N8 10k
L1 N0 N7 10n
L2 N5 N10 10n
L3 N5 N11 10n
L4 N0 N6 10n

.control
set filetype=ascii

op
let power_dc = abs(i(VLABEL_NET_0)) * 1.8
print power_dc
let dc_voltage = v(N0)
print dc_voltage

quit
.endc

.end
