* Testcase 000257 — Full Analysis (sky130 tt corner)
* SKY130 model header — replaces the ideal level-1 .model cards
* Ships with the demo; the paths point at the local sky130 PDK checkout.
* NOTE: libs.tech/ngspice/all.spice sets ".option scale=1.0u", so every
* instance L/W below is written in microns WITHOUT a "u" suffix.
.param mc_mm_switch=0
.param mc_pr_switch=0
.include /home/idies/workspace/Temporary/xyu1/scratch/skywater-pdk-libs-sky130_fd_pr/models/corners/tt.spice
.include /home/idies/workspace/Temporary/xyu1/scratch/skywater-pdk-libs-sky130_fd_pr/models/r+c/res_typical__cap_typical.spice
.include /home/idies/workspace/Temporary/xyu1/scratch/skywater-pdk-libs-sky130_fd_pr/models/r+c/res_typical__cap_typical__lin.spice
.include /home/idies/workspace/Temporary/xyu1/scratch/skywater-pdk-libs-sky130_fd_pr/models/corners/tt/specialized_cells.spice
.model DIDEAL D   is=1e-14 n=1
.options reltol=1e-3 itl1=500 itl2=100

* Sources
VINPUT INPUT 0 DC 0.9 AC 1 SIN(0.9 0.1 1MEG 0 0)

* Circuit
R1 N1 MINUS_5V 10k
I1 N11 MINUS_5V 1u
R2 N3 MINUS_5V 10k
R3 N2 MINUS_5V 10k
R4 N4 MINUS_5V 10k
XQ1 GND N5 N8 0 sky130_fd_pr__npn_05v5_W1p00L1p00
R5 GND N5 10k
XQ2 N3 N3 N11 0 sky130_fd_pr__npn_05v5_W1p00L1p00
R6 GND N10 10k
R7 N8 INPUT 10k
XQ3 OUTPUT N1 N11 0 sky130_fd_pr__npn_05v5_W1p00L1p00
XQ4 GND N2 N1 0 sky130_fd_pr__npn_05v5_W1p00L1p00
XQ5 N5 INPUT N12 0 sky130_fd_pr__npn_05v5_W1p00L1p00
R8 N7 INPUT 10k
XQ6 N10 INPUT N12 0 sky130_fd_pr__npn_05v5_W1p00L1p00
XQ7 GND N5 N2 0 sky130_fd_pr__npn_05v5_W1p00L1p00
XQ8 GND N10 N7 0 sky130_fd_pr__npn_05v5_W1p00L1p00
XQ9 GND N4 N3 0 sky130_fd_pr__npn_05v5_W1p00L1p00
XQ10 GND N10 N4 0 sky130_fd_pr__npn_05v5_W1p00L1p00
I2 N12 MINUS_5V 1u

.control
set filetype=ascii

op
let vdd_current = abs(i(VVDD))
let power_dc = vdd_current * 1.8
print power_dc

ac dec 100 1 10g
let vout_mag = vm(OUTPUT)
let gain_db = db(vout_mag)
let dc_gain_db = gain_db[0]
print dc_gain_db

if dc_gain_db > 0
    meas ac ugbw WHEN gain_db=0 CROSS=1
end

quit
.endc

.end
