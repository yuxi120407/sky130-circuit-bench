* Testcase 000218 — Full Analysis (sky130 tt corner)
* SKY130 model header — replaces the ideal level-1 .model cards
* Ships with the demo; the paths point at the local sky130 PDK checkout.
* NOTE: libs.tech/ngspice/all.spice sets ".option scale=1.0u", so every
* instance L/W below is written in microns WITHOUT a "u" suffix.
.param mc_mm_switch=0
.param mc_pr_switch=0
.include /home/idies/workspace/Temporary/xyu1/scratch/skywater-pdk-libs-sky130_fd_pr/models/corners/tt.spice
.include /home/idies/workspace/Temporary/xyu1/scratch/skywater-pdk-libs-sky130_fd_pr/models/r+c/res_typical__cap_typical.spice
.include /home/idies/workspace/Temporary/xyu1/scratch/skywater-pdk-libs-sky130_fd_pr/models/r+c/res_typical__cap_typical__lin.spice
.include /home/idies/workspace/Temporary/xyu1/scratch/skywater-pdk-libs-sky130_fd_pr/models/corners/tt/specialized_cells.spice
.model DIDEAL D   is=1e-14 n=1
.options reltol=1e-3 itl1=500 itl2=100

* Sources
VVDD VDD 0 1.8
VVCM_CTRL VCM_CTRL 0 0.9
VIN_MINUS IN_MINUS 0 DC 0.9 AC -0.5
VLABEL_NET_1 LABEL_NET_1 0 0.9
VIN_PLUS IN_PLUS 0 DC 0.9 AC 0.5

* Circuit
XMS3 OUT_MINUS VCM_CTRL VDD VDD sky130_fd_pr__pfet_01v8 l=0.5 w=5
XM2 OUT_PLUS IN_MINUS N0 GND sky130_fd_pr__nfet_01v8 l=0.5 w=5
XM3 N0 LABEL_NET_1 GND GND sky130_fd_pr__nfet_01v8 l=0.5 w=5
XM4 OUT_MINUS IN_PLUS N0 GND sky130_fd_pr__nfet_01v8 l=0.5 w=5
XMS4 OUT_PLUS VCM_CTRL VDD VDD sky130_fd_pr__pfet_01v8 l=0.5 w=5

.control
set filetype=ascii

op
let power_dc = abs(i(VVDD)) * 1.8
let vout_dc = v(OUT_PLUS)
print power_dc vout_dc

ac dec 100 1 10g
let gain_db = db(vm(OUT_PLUS))
meas ac dc_gain_db FIND gain_db AT=1
meas ac ugbw WHEN gain_db=0 CROSS=1
print dc_gain_db ugbw

quit
.endc

.end
