* Testcase 001241 — Full Analysis (sky130 tt corner)
* SKY130 model header — replaces the ideal level-1 .model cards
* Ships with the demo; the paths point at the local sky130 PDK checkout.
* NOTE: libs.tech/ngspice/all.spice sets ".option scale=1.0u", so every
* instance L/W below is written in microns WITHOUT a "u" suffix.
.param mc_mm_switch=0
.param mc_pr_switch=0
.include /home/idies/workspace/Temporary/xyu1/scratch/skywater-pdk-libs-sky130_fd_pr/models/corners/tt.spice
.include /home/idies/workspace/Temporary/xyu1/scratch/skywater-pdk-libs-sky130_fd_pr/models/r+c/res_typical__cap_typical.spice
.include /home/idies/workspace/Temporary/xyu1/scratch/skywater-pdk-libs-sky130_fd_pr/models/r+c/res_typical__cap_typical__lin.spice
.include /home/idies/workspace/Temporary/xyu1/scratch/skywater-pdk-libs-sky130_fd_pr/models/corners/tt/specialized_cells.spice
.model DIDEAL D   is=1e-14 n=1
.options reltol=1e-3 itl1=500 itl2=100

* Sources
VVREF VREF 0 DC 0.9 AC 0.5
VVB VB 0 0.75

* Circuit
D1 N11 VCTX DIDEAL
XQ2 VCC N6 N5 0 sky130_fd_pr__npn_05v5_W1p00L1p00
C1 N6 N11 1p
I1 N5 VEE 1u
C2 VEE N5 1p
L1 N6 VCC 10n
XQ1 VCC N8 N5 0 sky130_fd_pr__npn_05v5_W1p00L1p00
R1 VEE N12 10k
R2 VEE N17 10k
C6 N1 N6 1p
XQ3 N6 N2 N13 0 sky130_fd_pr__npn_05v5_W1p00L1p00
C4 N3 N8 1p
C5 N13 N14 1p
C3 N2 N8 1p
XQ4 N8 N1 N14 0 sky130_fd_pr__npn_05v5_W1p00L1p00
XQ5 N14 N7 N12 0 sky130_fd_pr__npn_05v5_W1p00L1p00
XQ6 N13 N7 N17 0 sky130_fd_pr__npn_05v5_W1p00L1p00
L2 N8 N8 10n
D2 N11 VCF0 DIDEAL
R3 N2 VB 10k
R4 N1 VB 10k
D3 N3 VCF0 DIDEAL
D4 N3 VCTX DIDEAL

.control
set filetype=ascii

op
let power_dc = abs(i(VVREF)) * 1.8
print power_dc
let dc_voltage = v(N1)
print dc_voltage

quit
.endc

.end
