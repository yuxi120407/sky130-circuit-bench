* Testcase 000502 — Full Analysis (sky130 tt corner)
* SKY130 model header — replaces the ideal level-1 .model cards
* Ships with the demo; the paths point at the local sky130 PDK checkout.
* NOTE: libs.tech/ngspice/all.spice sets ".option scale=1.0u", so every
* instance L/W below is written in microns WITHOUT a "u" suffix.
.param mc_mm_switch=0
.param mc_pr_switch=0
.include /home/idies/workspace/Temporary/xyu1/scratch/skywater-pdk-libs-sky130_fd_pr/models/corners/tt.spice
.include /home/idies/workspace/Temporary/xyu1/scratch/skywater-pdk-libs-sky130_fd_pr/models/r+c/res_typical__cap_typical.spice
.include /home/idies/workspace/Temporary/xyu1/scratch/skywater-pdk-libs-sky130_fd_pr/models/r+c/res_typical__cap_typical__lin.spice
.include /home/idies/workspace/Temporary/xyu1/scratch/skywater-pdk-libs-sky130_fd_pr/models/corners/tt/specialized_cells.spice
.model DIDEAL D   is=1e-14 n=1
.options reltol=1e-3 itl1=500 itl2=100

* Sources
VVDD VDD 0 1.8
VVSS VSS 0 DC 0 AC 0.5
VVB VB 0 0.75

* Circuit
XM1 COSN N1 IF VDD sky130_fd_pr__pfet_01v8 l=0.5 w=5
XM2 COSN N2 IF VDD sky130_fd_pr__pfet_01v8 l=0.5 w=5
XM3 COSP N1 IF VDD sky130_fd_pr__pfet_01v8 l=0.5 w=5
XM4 COSP N2 IF VDD sky130_fd_pr__pfet_01v8 l=0.5 w=5
XM5 SINN N4 IF VDD sky130_fd_pr__pfet_01v8 l=0.5 w=5
XM6 SINN N3 IF VDD sky130_fd_pr__pfet_01v8 l=0.5 w=5
XM7 SINP N4 IF VDD sky130_fd_pr__pfet_01v8 l=0.5 w=5
XM8 SINP N3 IF VDD sky130_fd_pr__pfet_01v8 l=0.5 w=5
XM9 N1 SMP VL VSS sky130_fd_pr__nfet_01v8 l=0.5 w=5
XM10 N2 SMP VR VSS sky130_fd_pr__nfet_01v8 l=0.5 w=5
XM11 N3 SMP VT VSS sky130_fd_pr__nfet_01v8 l=0.5 w=5
XM12 N4 SMP VB VSS sky130_fd_pr__nfet_01v8 l=0.5 w=5
XM13 IF IF VSS VSS sky130_fd_pr__nfet_01v8 l=0.5 w=5
XM14 IF IF VSS VSS sky130_fd_pr__nfet_01v8 l=0.5 w=5

.control
set filetype=ascii

op
let power_dc = abs(i(VVDD)) * 1.8
print power_dc

ac dec 100 1 10g
let vout_mag = vm(N1)
let gain_db = db(vout_mag)
let dc_gain_db = gain_db[0]
print dc_gain_db

if dc_gain_db > 0
    meas ac ugbw WHEN gain_db=0 CROSS=1
    print ugbw
end

quit
.endc

.end
