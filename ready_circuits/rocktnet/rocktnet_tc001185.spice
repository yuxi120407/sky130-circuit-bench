* Testcase 001185 — Full Analysis (sky130 tt corner)
* SKY130 model header — replaces the ideal level-1 .model cards
* Ships with the demo; the paths point at the local sky130 PDK checkout.
* NOTE: libs.tech/ngspice/all.spice sets ".option scale=1.0u", so every
* instance L/W below is written in microns WITHOUT a "u" suffix.
.param mc_mm_switch=0
.param mc_pr_switch=0
.include /home/idies/workspace/Temporary/xyu1/scratch/skywater-pdk-libs-sky130_fd_pr/models/corners/tt.spice
.include /home/idies/workspace/Temporary/xyu1/scratch/skywater-pdk-libs-sky130_fd_pr/models/r+c/res_typical__cap_typical.spice
.include /home/idies/workspace/Temporary/xyu1/scratch/skywater-pdk-libs-sky130_fd_pr/models/r+c/res_typical__cap_typical__lin.spice
.include /home/idies/workspace/Temporary/xyu1/scratch/skywater-pdk-libs-sky130_fd_pr/models/corners/tt/specialized_cells.spice
.model DIDEAL D   is=1e-14 n=1
.options reltol=1e-3 itl1=500 itl2=100

* Sources
VVDD VDD 0 1.8
VVIN VIN 0 DC 0.9 AC 1 SIN(0.9 0.1 1MEG 0 0)
VLABEL_NET_2 LABEL_NET_2 0 0.9

* Circuit
I1 N11 GND 1u
L1 N10 TO_BALUN 10n
L2 VDD N9 10n
L3 N3 N8 10n
XM1 GND N3 GND GND sky130_fd_pr__nfet_01v8 l=0.5 w=5
L4 VDD N10 10n
L5 N4 GND 10n
L6 VDD N6 10n
L7 N9 TO_BALUN 10n
L8 VDD N1 10n
L9 VDD N7 10n
L10 VDD N0 10n
XM2 N9 N9 N12 GND sky130_fd_pr__nfet_01v8 l=0.5 w=5
XM3 N7 VIN N11 GND sky130_fd_pr__nfet_01v8 l=0.5 w=5
XM4 N6 N11 N11 GND sky130_fd_pr__nfet_01v8 l=0.5 w=5
XM5 N13 N5 GND GND sky130_fd_pr__nfet_01v8 l=0.5 w=5
C1 N4 GND 1p
C2 N8 GND 1p
L11 N12 GND 10n
XM6 N0 LABEL_NET_2 N15 GND sky130_fd_pr__nfet_01v8 l=0.5 w=5
XM7 GND GND GND GND sky130_fd_pr__nfet_01v8 l=0.5 w=5
C3 N1 N3 1p
C4 N2 N7 1p
C5 N0 GND 1p
C6 N5 N6 1p
XM8 N13 N2 GND GND sky130_fd_pr__nfet_01v8 l=0.5 w=5
XM9 N1 N1 N15 GND sky130_fd_pr__nfet_01v8 l=0.5 w=5
XM10 N10 N10 N12 GND sky130_fd_pr__nfet_01v8 l=0.5 w=5

.control
set filetype=ascii

op
let vdd_current = abs(i(VVDD))
let power_dc = vdd_current * 1.8
print power_dc

ac dec 100 1k 100g
let vout_mag = vm(N4)
let gain_db = db(vout_mag)

meas ac max_gain_db MAX gain_db
meas ac bw_3db WHEN gain_db='max_gain_db-3' CROSS=1

print max_gain_db bw_3db

quit
.endc

.end
