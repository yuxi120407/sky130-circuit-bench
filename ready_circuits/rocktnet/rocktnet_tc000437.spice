* Testcase 000437 — Full Analysis (sky130 tt corner)
* SKY130 model header — replaces the ideal level-1 .model cards
* Ships with the demo; the paths point at the local sky130 PDK checkout.
* NOTE: libs.tech/ngspice/all.spice sets ".option scale=1.0u", so every
* instance L/W below is written in microns WITHOUT a "u" suffix.
.param mc_mm_switch=0
.param mc_pr_switch=0
.include /home/idies/workspace/Temporary/xyu1/scratch/skywater-pdk-libs-sky130_fd_pr/models/corners/tt.spice
.include /home/idies/workspace/Temporary/xyu1/scratch/skywater-pdk-libs-sky130_fd_pr/models/r+c/res_typical__cap_typical.spice
.include /home/idies/workspace/Temporary/xyu1/scratch/skywater-pdk-libs-sky130_fd_pr/models/r+c/res_typical__cap_typical__lin.spice
.include /home/idies/workspace/Temporary/xyu1/scratch/skywater-pdk-libs-sky130_fd_pr/models/corners/tt/specialized_cells.spice
.model DIDEAL D   is=1e-14 n=1
.options reltol=1e-3 itl1=500 itl2=100

* Sources
VIN IN 0 DC 0.9 AC 1 SIN(0.9 0.1 1MEG 0 0)
VLABEL_NET_0 LABEL_NET_0 0 0.9

* Circuit
R1 GND IN 10k
XQ1 GND N2 N7 0 sky130_fd_pr__npn_05v5_W1p00L1p00
XQ2 N3 N3 N17 0 sky130_fd_pr__npn_05v5_W1p00L1p00
XQ3 N2 N2 N10 0 sky130_fd_pr__npn_05v5_W1p00L1p00
XQ4 IN N0 N11 0 sky130_fd_pr__npn_05v5_W1p00L1p00
XQ5 N8 IN N19 0 sky130_fd_pr__npn_05v5_W1p00L1p00
R2 N7 N12 10k
XQ6 OUT N7 N20 0 sky130_fd_pr__npn_05v5_W1p00L1p00
R3 N11 N12 10k
R4 GND OUT 10k
R5 N1 N12 10k
R6 N10 N12 10k
XQ7 N19 N0 N15 0 sky130_fd_pr__npn_05v5_W1p00L1p00
XQ8 N14 IN N0 0 sky130_fd_pr__npn_05v5_W1p00L1p00
XQ9 N9 N0 N13 0 sky130_fd_pr__npn_05v5_W1p00L1p00
XQ10 N18 N18 N14 0 sky130_fd_pr__npn_05v5_W1p00L1p00
R7 N12 N15 10k
R8 N12 N17 10k
RL2 N4 GND 10k
R10 N12 N13 10k
RE1 N9 N9 10k
RL1 GND N8 10k
XQ11 N4 IN N19 0 sky130_fd_pr__npn_05v5_W1p00L1p00
RE2 N9 N20 10k
RFB2 N2 IN 10k
R15 GND OUT 10k
RFB1 N3 IN 10k
XQ12 GND N4 N2 0 sky130_fd_pr__npn_05v5_W1p00L1p00
XQ13 GND GND N18 0 sky130_fd_pr__npn_05v5_W1p00L1p00
XQ14 OUT N1 LABEL_NET_0 0 sky130_fd_pr__npn_05v5_W1p00L1p00
XQ15 N3 N8 GND sky130_fd_pr__pnp_05v5_W3p40L3p40
XQ16 N1 N3 GND sky130_fd_pr__pnp_05v5_W3p40L3p40

.control
set filetype=ascii

op
let vdd_current = abs(i(VVDD))
let power_dc = vdd_current * 1.8
print power_dc

ac dec 100 1 10g
let vout_mag = vm(OUT)
let gain_db = db(vout_mag)
let dc_gain_db = gain_db[0]
print dc_gain_db

if dc_gain_db > 0
    meas ac ugbw WHEN gain_db=0 CROSS=1
end

quit
.endc

.end
