* Testcase 000445 — Full Analysis (sky130 tt corner)
* SKY130 model header — replaces the ideal level-1 .model cards
* Ships with the demo; the paths point at the local sky130 PDK checkout.
* NOTE: libs.tech/ngspice/all.spice sets ".option scale=1.0u", so every
* instance L/W below is written in microns WITHOUT a "u" suffix.
.param mc_mm_switch=0
.param mc_pr_switch=0
.include /home/idies/workspace/Temporary/xyu1/scratch/skywater-pdk-libs-sky130_fd_pr/models/corners/tt.spice
.include /home/idies/workspace/Temporary/xyu1/scratch/skywater-pdk-libs-sky130_fd_pr/models/r+c/res_typical__cap_typical.spice
.include /home/idies/workspace/Temporary/xyu1/scratch/skywater-pdk-libs-sky130_fd_pr/models/r+c/res_typical__cap_typical__lin.spice
.include /home/idies/workspace/Temporary/xyu1/scratch/skywater-pdk-libs-sky130_fd_pr/models/corners/tt/specialized_cells.spice
.model DIDEAL D   is=1e-14 n=1
.options reltol=1e-3 itl1=500 itl2=100

* Sources
VVBIAS VBIAS 0 0.54

* Circuit
R1 VCC IFON 10k
R2 VCC IFOP 10k
XQ1 IFON LOIN N1_D 0 sky130_fd_pr__npn_05v5_W1p00L1p00
XQ2 IFOP LOIP N1_D 0 sky130_fd_pr__npn_05v5_W1p00L1p00
XQ5 IFON LOQN N2_D 0 sky130_fd_pr__npn_05v5_W1p00L1p00
XQ6 IFOP LOQP N2_D 0 sky130_fd_pr__npn_05v5_W1p00L1p00
XQ3 IFON LOQN N3_D 0 sky130_fd_pr__npn_05v5_W1p00L1p00
XQ4 IFOP LOQP N3_D 0 sky130_fd_pr__npn_05v5_W1p00L1p00
XQ7 IFON LOIN N4_D 0 sky130_fd_pr__npn_05v5_W1p00L1p00
XQ8 IFOP LOIP N4_D 0 sky130_fd_pr__npn_05v5_W1p00L1p00
XN1 N1_D BBIN N5 GND sky130_fd_pr__nfet_01v8 l=0.5 w=5
XN3 N2_D BBQP N7 GND sky130_fd_pr__nfet_01v8 l=0.5 w=5
XN2 N3_D BBIQ N6 GND sky130_fd_pr__nfet_01v8 l=0.5 w=5
XN4 N4_D BBQN N8 GND sky130_fd_pr__nfet_01v8 l=0.5 w=5
XN5 N5 VBIAS GND GND sky130_fd_pr__nfet_01v8 l=0.5 w=5
XN6 N6 VBIAS GND GND sky130_fd_pr__nfet_01v8 l=0.5 w=5
XN7 N7 VBIAS GND GND sky130_fd_pr__nfet_01v8 l=0.5 w=5
XN8 N8 VBIAS GND GND sky130_fd_pr__nfet_01v8 l=0.5 w=5
R3 N5 N6 10k
R4 N7 N8 10k

.control
set filetype=ascii

op
let power_dc = abs(i(VVBIAS)) * 1.8
print power_dc
let dc_voltage = v(IFON)
print dc_voltage

quit
.endc

.end
