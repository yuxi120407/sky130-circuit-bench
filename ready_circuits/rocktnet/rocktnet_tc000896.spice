* Testcase 000896 — Full Analysis (sky130 tt corner)
* SKY130 model header — replaces the ideal level-1 .model cards
* Ships with the demo; the paths point at the local sky130 PDK checkout.
* NOTE: libs.tech/ngspice/all.spice sets ".option scale=1.0u", so every
* instance L/W below is written in microns WITHOUT a "u" suffix.
.param mc_mm_switch=0
.param mc_pr_switch=0
.include /home/idies/workspace/Temporary/xyu1/scratch/skywater-pdk-libs-sky130_fd_pr/models/corners/tt.spice
.include /home/idies/workspace/Temporary/xyu1/scratch/skywater-pdk-libs-sky130_fd_pr/models/r+c/res_typical__cap_typical.spice
.include /home/idies/workspace/Temporary/xyu1/scratch/skywater-pdk-libs-sky130_fd_pr/models/r+c/res_typical__cap_typical__lin.spice
.include /home/idies/workspace/Temporary/xyu1/scratch/skywater-pdk-libs-sky130_fd_pr/models/corners/tt/specialized_cells.spice
.model DIDEAL D   is=1e-14 n=1
.options reltol=1e-3 itl1=500 itl2=100

* Sources

* Circuit
R1 N16 VEE 10k
R2 N5 VEE 10k
R3 VCC IOUT 10k
XQ1 N11 N11 N16 0 sky130_fd_pr__npn_05v5_W1p00L1p00
R4 IOUT N11 10k
XQ2 VCC N12 N4 0 sky130_fd_pr__npn_05v5_W1p00L1p00
R5 VCC Q 10k
R6 VCC QN 10k
R7 N8 VEE 10k
XQ3 N3 N11 N5 0 sky130_fd_pr__npn_05v5_W1p00L1p00
R8 N4 VEE 10k
R9 N1 VEE 10k
R10 N14 VEE 10k
XQ4 VCC D1N N0 0 sky130_fd_pr__npn_05v5_W1p00L1p00
R11 N6 VEE 10k
XQ5 N19 N15 N3 0 sky130_fd_pr__npn_05v5_W1p00L1p00
R12 N15 VEE 10k
XQ6 VCC N18 N12 0 sky130_fd_pr__npn_05v5_W1p00L1p00
R13 N12 VEE 10k
XQ7 QN N8 N7 0 sky130_fd_pr__npn_05v5_W1p00L1p00
R14 N0 VEE 10k
XQ8 VCC CLK N14 0 sky130_fd_pr__npn_05v5_W1p00L1p00
XQ9 VCC N14 N15 0 sky130_fd_pr__npn_05v5_W1p00L1p00
XQ10 VCC D1 N1 0 sky130_fd_pr__npn_05v5_W1p00L1p00
XQ11 QN N0 N19 0 sky130_fd_pr__npn_05v5_W1p00L1p00
XQ12 VCC D2N N8 0 sky130_fd_pr__npn_05v5_W1p00L1p00
XQ13 VCC D2 N6 0 sky130_fd_pr__npn_05v5_W1p00L1p00
XQ14 Q N6 N7 0 sky130_fd_pr__npn_05v5_W1p00L1p00
R15 IOUT IOUT 10k
XQ15 Q N1 N19 0 sky130_fd_pr__npn_05v5_W1p00L1p00
XQ16 N3 N4 N7 sky130_fd_pr__pnp_05v5_W3p40L3p40
R16 N18 CLKN 10k

.control
set filetype=ascii

op
let power_dc = 0
print power_dc
let dc_voltage = v(CLKN)
print dc_voltage

quit
.endc

.end
