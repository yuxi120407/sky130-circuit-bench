* Testcase 000898 — Full Analysis (sky130 tt corner)
* SKY130 model header — replaces the ideal level-1 .model cards
* Ships with the demo; the paths point at the local sky130 PDK checkout.
* NOTE: libs.tech/ngspice/all.spice sets ".option scale=1.0u", so every
* instance L/W below is written in microns WITHOUT a "u" suffix.
.param mc_mm_switch=0
.param mc_pr_switch=0
.include /home/idies/workspace/Temporary/xyu1/scratch/skywater-pdk-libs-sky130_fd_pr/models/corners/tt.spice
.include /home/idies/workspace/Temporary/xyu1/scratch/skywater-pdk-libs-sky130_fd_pr/models/r+c/res_typical__cap_typical.spice
.include /home/idies/workspace/Temporary/xyu1/scratch/skywater-pdk-libs-sky130_fd_pr/models/r+c/res_typical__cap_typical__lin.spice
.include /home/idies/workspace/Temporary/xyu1/scratch/skywater-pdk-libs-sky130_fd_pr/models/corners/tt/specialized_cells.spice
.model DIDEAL D   is=1e-14 n=1
.options reltol=1e-3 itl1=500 itl2=100

* Sources
VVDD VDD 0 1.8
VVINp VINp 0 DC 0.9 AC 1 SIN(0.9 0.1 1MEG 0 0)
VVINn VINn 0 DC 0.9 AC 1 SIN(0.9 0.1 1MEG 0 0)
VVBIAS VBIAS 0 0.54

* Circuit
R1 VDD N4 10k
R2 VOUTp VDD 10k
XQ1 VOUTp N5 N3 0 sky130_fd_pr__npn_05v5_W1p00L1p00
C1 VOUTn GND 1p
XQ2 N5 VINp N7 0 sky130_fd_pr__npn_05v5_W1p00L1p00
R3 VDD N5 10k
XQ3 VOUTn N4 N3 0 sky130_fd_pr__npn_05v5_W1p00L1p00
XQ4 N4 VINn N7 0 sky130_fd_pr__npn_05v5_W1p00L1p00
R4 VOUTn VDD 10k
C2 VOUTp GND 1p
XM1 N7 VBIAS GND GND sky130_fd_pr__nfet_01v8 l=0.5 w=5
XM2 N3 VBIAS GND GND sky130_fd_pr__nfet_01v8 l=0.5 w=5

.control
set filetype=ascii

op
let vdd_current = abs(i(VVDD))
let power_dc = vdd_current * 1.8
print power_dc

ac dec 100 1 10g
let vout_mag = vm(VOUTn)
let gain_db = db(vout_mag)
let dc_gain_db = gain_db[0]
print dc_gain_db

if dc_gain_db > 0
    meas ac ugbw WHEN gain_db=0 CROSS=1
end

quit
.endc

.end
