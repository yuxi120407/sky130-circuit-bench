* Testcase 001092 — Full Analysis (sky130 tt corner)
* SKY130 model header — replaces the ideal level-1 .model cards
* Ships with the demo; the paths point at the local sky130 PDK checkout.
* NOTE: libs.tech/ngspice/all.spice sets ".option scale=1.0u", so every
* instance L/W below is written in microns WITHOUT a "u" suffix.
.param mc_mm_switch=0
.param mc_pr_switch=0
.include /home/idies/workspace/Temporary/xyu1/scratch/skywater-pdk-libs-sky130_fd_pr/models/corners/tt.spice
.include /home/idies/workspace/Temporary/xyu1/scratch/skywater-pdk-libs-sky130_fd_pr/models/r+c/res_typical__cap_typical.spice
.include /home/idies/workspace/Temporary/xyu1/scratch/skywater-pdk-libs-sky130_fd_pr/models/r+c/res_typical__cap_typical__lin.spice
.include /home/idies/workspace/Temporary/xyu1/scratch/skywater-pdk-libs-sky130_fd_pr/models/corners/tt/specialized_cells.spice
.model DIDEAL D   is=1e-14 n=1
.options reltol=1e-3 itl1=500 itl2=100

* Sources
VVDD VDD 0 1.8

* Circuit
XM7 N_M7_D N_M7_D VDD VDD sky130_fd_pr__pfet_01v8 l=0.5 w=5
XM8 V_OUT N_M7_D VDD VDD sky130_fd_pr__pfet_01v8 l=0.5 w=5
XM6 N_M7_D V_IN1 N_TAIL GND sky130_fd_pr__nfet_01v8 l=0.5 w=5
XM2 V_OUT V_IN2 N_TAIL GND sky130_fd_pr__nfet_01v8 l=0.5 w=5
XM3 N_I0_BOT V_OUT N_TAIL GND sky130_fd_pr__nfet_01v8 l=0.5 w=5
XM5 N_TAIL N_I0_BOT GND GND sky130_fd_pr__nfet_01v8 l=0.5 w=5
XM9 V_IN1 V_IN1 N_M9_S GND sky130_fd_pr__nfet_01v8 l=0.5 w=5
XM1 V_IN2 V_IN2 N_M1_S GND sky130_fd_pr__nfet_01v8 l=0.5 w=5
XM4 I_OUT V_OUT N_M4_S GND sky130_fd_pr__nfet_01v8 l=0.5 w=5
C V_OUT GND 1p
I0 VDD N_I0_BOT 1u
I1 N_M9_S GND 1u
I2 N_M1_S GND 1u
I3 N_M4_S GND 1u

.control
set filetype=ascii

op
let vdd_current = abs(i(VVDD))
let power_dc = vdd_current * 1.8
print power_dc

ac dec 100 1 10g
let vout_mag = vm(V_OUT)
let gain_db = db(vout_mag)
let dc_gain_db = gain_db[0]
print dc_gain_db

if dc_gain_db > 0
    meas ac ugbw WHEN gain_db=0 CROSS=1
end

quit
.endc

.end
