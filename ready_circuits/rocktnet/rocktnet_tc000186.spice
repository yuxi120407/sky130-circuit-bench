* Testcase 000186 — Full Analysis (sky130 tt corner)
* SKY130 model header — replaces the ideal level-1 .model cards
* Ships with the demo; the paths point at the local sky130 PDK checkout.
* NOTE: libs.tech/ngspice/all.spice sets ".option scale=1.0u", so every
* instance L/W below is written in microns WITHOUT a "u" suffix.
.param mc_mm_switch=0
.param mc_pr_switch=0
.include /home/idies/workspace/Temporary/xyu1/scratch/skywater-pdk-libs-sky130_fd_pr/models/corners/tt.spice
.include /home/idies/workspace/Temporary/xyu1/scratch/skywater-pdk-libs-sky130_fd_pr/models/r+c/res_typical__cap_typical.spice
.include /home/idies/workspace/Temporary/xyu1/scratch/skywater-pdk-libs-sky130_fd_pr/models/r+c/res_typical__cap_typical__lin.spice
.include /home/idies/workspace/Temporary/xyu1/scratch/skywater-pdk-libs-sky130_fd_pr/models/corners/tt/specialized_cells.spice
.model DIDEAL D   is=1e-14 n=1
.options reltol=1e-3 itl1=500 itl2=100

* Sources
VVDD VDD 0 1.8
VVREF VREF 0 0.9
VIBIAS IBIAS 0 0.54
VVBIAS2 VBIAS2 0 0.9900000000000001
VVBIAS3 VBIAS3 0 0.9900000000000001
VVBIAS1 VBIAS1 0 0.54

* Circuit
XM2 VREF IBIAS GND GND sky130_fd_pr__nfet_01v8 l=0.5 w=5
XM1 IBIAS IBIAS GND GND sky130_fd_pr__nfet_01v8 l=0.5 w=5
XM10 VBIAS2 VBIAS3 N7 VDD sky130_fd_pr__pfet_01v8 l=0.5 w=5
XM3 VBIAS3 IBIAS GND GND sky130_fd_pr__nfet_01v8 l=0.5 w=5
XM12 VBIAS1 VBIAS3 N1 VDD sky130_fd_pr__pfet_01v8 l=0.5 w=5
XM4 VBIAS2 IBIAS GND GND sky130_fd_pr__nfet_01v8 l=0.5 w=5
I1 VDD IBIAS 1u
XM5 VBIAS1 VBIAS1 GND GND sky130_fd_pr__nfet_01v8 l=0.5 w=5
XM9 N7 VBIAS2 VDD VDD sky130_fd_pr__pfet_01v8 l=0.5 w=5
XM11 N1 VBIAS2 VDD VDD sky130_fd_pr__pfet_01v8 l=0.5 w=5
XM7 VREF VREF VDD VDD sky130_fd_pr__pfet_01v8 l=0.5 w=5
XM8 VBIAS3 VBIAS3 VDD VDD sky130_fd_pr__pfet_01v8 l=0.5 w=5

.control
set filetype=ascii

op
let vdd_current = abs(i(VVDD))
let power_dc = vdd_current * 1.8
print power_dc

print all

quit
.endc

.end
