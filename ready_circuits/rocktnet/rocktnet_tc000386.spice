* Testcase 000386 — Full Analysis (sky130 tt corner)
* SKY130 model header — replaces the ideal level-1 .model cards
* Ships with the demo; the paths point at the local sky130 PDK checkout.
* NOTE: libs.tech/ngspice/all.spice sets ".option scale=1.0u", so every
* instance L/W below is written in microns WITHOUT a "u" suffix.
.param mc_mm_switch=0
.param mc_pr_switch=0
.include /home/idies/workspace/Temporary/xyu1/scratch/skywater-pdk-libs-sky130_fd_pr/models/corners/tt.spice
.include /home/idies/workspace/Temporary/xyu1/scratch/skywater-pdk-libs-sky130_fd_pr/models/r+c/res_typical__cap_typical.spice
.include /home/idies/workspace/Temporary/xyu1/scratch/skywater-pdk-libs-sky130_fd_pr/models/r+c/res_typical__cap_typical__lin.spice
.include /home/idies/workspace/Temporary/xyu1/scratch/skywater-pdk-libs-sky130_fd_pr/models/corners/tt/specialized_cells.spice
.model DIDEAL D   is=1e-14 n=1
.options reltol=1e-3 itl1=500 itl2=100

* Sources
VVDD VDD 0 1.8
VVBIAS VBIAS 0 DC 0.54 AC 0.5

* Circuit
L1 VDD N1 10n
XM1 N5 N4 N3 GND sky130_fd_pr__nfet_01v8 l=0.5 w=5
L2 N3 GND 10n
R1 N2 GND 10k
XM2 IF_OUT LO N0 GND sky130_fd_pr__nfet_01v8 l=0.5 w=5
L3 N4 RF_IN 10n
XM3 IF_OUT_BAR LO_BAR N0 GND sky130_fd_pr__nfet_01v8 l=0.5 w=5
XM4 N1 VBIAS N5 GND sky130_fd_pr__nfet_01v8 l=0.5 w=5
XM5 N0 N2 GND GND sky130_fd_pr__nfet_01v8 l=0.5 w=5
C1 N1 N2 1p

.control
set filetype=ascii

op
let vdd_current = abs(i(VVDD))
let power_dc = vdd_current * 1.8
print power_dc

ac dec 100 1k 100g
let vout_mag = vm(N2)
let gain_db = db(vout_mag)

meas ac max_gain_db MAX gain_db
meas ac bw_3db WHEN gain_db='max_gain_db-3' CROSS=1

print max_gain_db bw_3db

quit
.endc

.end
