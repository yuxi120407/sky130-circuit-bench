* Testcase 000960 — Full Analysis (sky130 tt corner)
* SKY130 model header — replaces the ideal level-1 .model cards
* Ships with the demo; the paths point at the local sky130 PDK checkout.
* NOTE: libs.tech/ngspice/all.spice sets ".option scale=1.0u", so every
* instance L/W below is written in microns WITHOUT a "u" suffix.
.param mc_mm_switch=0
.param mc_pr_switch=0
.include /home/idies/workspace/Temporary/xyu1/scratch/skywater-pdk-libs-sky130_fd_pr/models/corners/tt.spice
.include /home/idies/workspace/Temporary/xyu1/scratch/skywater-pdk-libs-sky130_fd_pr/models/r+c/res_typical__cap_typical.spice
.include /home/idies/workspace/Temporary/xyu1/scratch/skywater-pdk-libs-sky130_fd_pr/models/r+c/res_typical__cap_typical__lin.spice
.include /home/idies/workspace/Temporary/xyu1/scratch/skywater-pdk-libs-sky130_fd_pr/models/corners/tt/specialized_cells.spice
.model DIDEAL D   is=1e-14 n=1
.options reltol=1e-2 abstol=1e-10 vntol=1e-4 itl1=1000 itl2=200 itl4=100
.options gmin=1e-10 method=gear

* Sources
VLABEL_NET_0 LABEL_NET_0 0 0.9
VLABEL_NET_1 LABEL_NET_1 0 0.9
VLABEL_NET_2 LABEL_NET_2 0 0.9
VLABEL_NET_3 LABEL_NET_3 0 0.9
VLABEL_NET_4 LABEL_NET_4 0 0.9
VLABEL_NET_5 LABEL_NET_5 0 0.9

* Circuit
XM1 N33 LABEL_NET_0 N34 GND sky130_fd_pr__nfet_01v8 l=0.5 w=5
XM2 N9 N17 N19 GND sky130_fd_pr__nfet_01v8 l=0.5 w=5
R1 N5 GND 10k
R2 N2 GND 10k
XM3 N9 N23 N20 GND sky130_fd_pr__nfet_01v8 l=0.5 w=5
XM4 N0 N34 N21 GND sky130_fd_pr__nfet_01v8 l=0.5 w=5
XM5 N1 N22 N23 GND sky130_fd_pr__nfet_01v8 l=0.5 w=5
XM6 N32 N18 N26 GND sky130_fd_pr__nfet_01v8 l=0.5 w=5
XM7 N15 N32 N35 GND sky130_fd_pr__nfet_01v8 l=0.5 w=5
R3 N7 GND 10k
XQ1 N10 N6 N4 0 sky130_fd_pr__npn_05v5_W1p00L1p00
R4 N3 GND 10k
XQ2 N2 LABEL_NET_1 N33 0 sky130_fd_pr__npn_05v5_W1p00L1p00
XM8 N26 LABEL_NET_2 N12 GND sky130_fd_pr__nfet_01v8 l=0.5 w=5
XM9 N35 N12 N24 GND sky130_fd_pr__nfet_01v8 l=0.5 w=5
XQ3 N5 LABEL_NET_3 N33 0 sky130_fd_pr__npn_05v5_W1p00L1p00
XM10 N20 N30 N14 GND sky130_fd_pr__nfet_01v8 l=0.5 w=5
XQ4 GND N2 N1 0 sky130_fd_pr__npn_05v5_W1p00L1p00
XQ5 N4 N6 N11 0 sky130_fd_pr__npn_05v5_W1p00L1p00
XQ6 GND N5 N0 0 sky130_fd_pr__npn_05v5_W1p00L1p00
XM11 N9 N31 N25 GND sky130_fd_pr__nfet_01v8 l=0.5 w=5
R5 N8 N16 10k
R6 N8 N29 10k
R7 N25 N8 10k
R8 N6 N9 10k
R9 N8 N14 10k
XM12 N23 N16 N13 GND sky130_fd_pr__nfet_01v8 l=0.5 w=5
XQ7 N11 N1 N9 0 sky130_fd_pr__npn_05v5_W1p00L1p00
XM13 N21 N29 N16 GND sky130_fd_pr__nfet_01v8 l=0.5 w=5
R10 N8 N12 10k
R11 N1 N1 10k
R12 N6 N9 10k
R13 N8 N24 10k
R14 N8 N13 10k
R15 N8 N27 10k
R16 N1 N15 10k
R17 N10 GND 10k
XQ8 N28 N0 N9 0 sky130_fd_pr__npn_05v5_W1p00L1p00
XQ9 GND N7 N6 0 sky130_fd_pr__npn_05v5_W1p00L1p00
XQ10 GND N10 N1 0 sky130_fd_pr__npn_05v5_W1p00L1p00
R18 N4 GND 10k
XM14 N19 LABEL_NET_4 N27 GND sky130_fd_pr__nfet_01v8 l=0.5 w=5
XM15 N34 LABEL_NET_5 N29 GND sky130_fd_pr__nfet_01v8 l=0.5 w=5
XQ11 N3 N1 N7 sky130_fd_pr__pnp_05v5_W3p40L3p40
XQ12 GND N4 N1 0 sky130_fd_pr__npn_05v5_W1p00L1p00
XQ13 N28 N1 N3 sky130_fd_pr__pnp_05v5_W3p40L3p40
XQ14 GND N3 N6 0 sky130_fd_pr__npn_05v5_W1p00L1p00

.control
set filetype=ascii

op
let power_dc = abs(i(VLABEL_NET_0)) * 1.8
print power_dc
let dc_voltage = v(N1)
print dc_voltage
print all

quit
.endc

.end
