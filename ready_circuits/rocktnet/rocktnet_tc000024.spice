* Testcase 000024 — Full Analysis (sky130 tt corner)
* SKY130 model header — replaces the ideal level-1 .model cards
* Ships with the demo; the paths point at the local sky130 PDK checkout.
* NOTE: libs.tech/ngspice/all.spice sets ".option scale=1.0u", so every
* instance L/W below is written in microns WITHOUT a "u" suffix.
.param mc_mm_switch=0
.param mc_pr_switch=0
.include /home/idies/workspace/Temporary/xyu1/scratch/skywater-pdk-libs-sky130_fd_pr/models/corners/tt.spice
.include /home/idies/workspace/Temporary/xyu1/scratch/skywater-pdk-libs-sky130_fd_pr/models/r+c/res_typical__cap_typical.spice
.include /home/idies/workspace/Temporary/xyu1/scratch/skywater-pdk-libs-sky130_fd_pr/models/r+c/res_typical__cap_typical__lin.spice
.include /home/idies/workspace/Temporary/xyu1/scratch/skywater-pdk-libs-sky130_fd_pr/models/corners/tt/specialized_cells.spice
.model DIDEAL D   is=1e-14 n=1
.options reltol=1e-3 itl1=500 itl2=100

* Sources
VVDD VDD 0 1.8
VLABEL_NET_0 LABEL_NET_0 0 0.9
VLABEL_NET_1 LABEL_NET_1 0 0.9

* Circuit
XM1 GND GND N7 VDD sky130_fd_pr__pfet_01v8 l=0.5 w=5
XM2 N10 N2 GND GND sky130_fd_pr__nfet_01v8 l=0.5 w=5
XM3 N4 N5 VDD VDD sky130_fd_pr__pfet_01v8 l=0.5 w=5
XM4 N7 N13 VDD VDD sky130_fd_pr__pfet_01v8 l=0.5 w=5
XM5 N13 N8 N4 VDD sky130_fd_pr__pfet_01v8 l=0.5 w=5
XM6 N5 N8 N11 VDD sky130_fd_pr__pfet_01v8 l=0.5 w=5
XM7 N13 GND N1 GND sky130_fd_pr__nfet_01v8 l=0.5 w=5
I1 N5 N2 1u
XM8 N9 N1 GND GND sky130_fd_pr__nfet_01v8 l=0.5 w=5
XM9 N12 GND GND VDD sky130_fd_pr__pfet_01v8 l=0.5 w=5
XM10 N3 N2 GND N10 sky130_fd_pr__nfet_01v8 l=0.5 w=5
XM11 N1 N0 N10 GND sky130_fd_pr__nfet_01v8 l=0.5 w=5
XM12 N1 LABEL_NET_0 N13 VDD sky130_fd_pr__pfet_01v8 l=0.5 w=5
XM13 GND GND N12 VDD sky130_fd_pr__pfet_01v8 l=0.5 w=5
XM14 N11 N5 VDD VDD sky130_fd_pr__pfet_01v8 l=0.5 w=5
XM15 N2 N0 N3 GND sky130_fd_pr__nfet_01v8 l=0.5 w=5
XM16 N12 N12 GND VDD sky130_fd_pr__pfet_01v8 l=0.5 w=5
XM17 GND GND N9 GND sky130_fd_pr__nfet_01v8 l=0.5 w=5
XM18 GND GND VDD VDD sky130_fd_pr__pfet_01v8 l=0.5 w=5
R1 N6 GND 10k
R2 N6 GND 10k

.control
set filetype=ascii

op
let vdd_current = abs(i(VVDD))
let power_dc = vdd_current * 1.8
let vout_dc = v(N6)
print power_dc vout_dc

quit
.endc

.end
