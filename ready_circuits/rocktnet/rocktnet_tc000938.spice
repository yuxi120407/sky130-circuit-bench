* Testcase 000938 — Full Analysis (sky130 tt corner)
* SKY130 model header — replaces the ideal level-1 .model cards
* Ships with the demo; the paths point at the local sky130 PDK checkout.
* NOTE: libs.tech/ngspice/all.spice sets ".option scale=1.0u", so every
* instance L/W below is written in microns WITHOUT a "u" suffix.
.param mc_mm_switch=0
.param mc_pr_switch=0
.include /home/idies/workspace/Temporary/xyu1/scratch/skywater-pdk-libs-sky130_fd_pr/models/corners/tt.spice
.include /home/idies/workspace/Temporary/xyu1/scratch/skywater-pdk-libs-sky130_fd_pr/models/r+c/res_typical__cap_typical.spice
.include /home/idies/workspace/Temporary/xyu1/scratch/skywater-pdk-libs-sky130_fd_pr/models/r+c/res_typical__cap_typical__lin.spice
.include /home/idies/workspace/Temporary/xyu1/scratch/skywater-pdk-libs-sky130_fd_pr/models/corners/tt/specialized_cells.spice
.model DIDEAL D   is=1e-14 n=1
.options reltol=1e-3 itl1=500 itl2=100

* Sources
VVDD VDD 0 1.8

* Circuit
IBIAS GND GND 1u
XM1 GND VSUM VDD VDD sky130_fd_pr__pfet_01v8 l=0.5 w=5
RF1 VSUM VSUM 10k
RF2 GND GND 10k
RMEMS VDD VR 10k
CF VSUM GND 1p
RREF VC GND 10k
CAC1 VSUM VR 1p
CAC2 VSUM VC 1p

.control
set filetype=ascii

op
let power_dc = abs(i(VVDD)) * 1.8
print power_dc
let dc_voltage_10k = v(10k)
print dc_voltage_10k
let dc_voltage_1p = v(1p)
print dc_voltage_1p
let dc_voltage_VC = v(VC)
print dc_voltage_VC
let dc_voltage_VR = v(VR)
print dc_voltage_VR
let dc_voltage_VSUM = v(VSUM)
print dc_voltage_VSUM

quit
.endc

.end
