* Testcase 001251 — Full Analysis (sky130 tt corner)
* SKY130 model header — replaces the ideal level-1 .model cards
* Ships with the demo; the paths point at the local sky130 PDK checkout.
* NOTE: libs.tech/ngspice/all.spice sets ".option scale=1.0u", so every
* instance L/W below is written in microns WITHOUT a "u" suffix.
.param mc_mm_switch=0
.param mc_pr_switch=0
.include /home/idies/workspace/Temporary/xyu1/scratch/skywater-pdk-libs-sky130_fd_pr/models/corners/tt.spice
.include /home/idies/workspace/Temporary/xyu1/scratch/skywater-pdk-libs-sky130_fd_pr/models/r+c/res_typical__cap_typical.spice
.include /home/idies/workspace/Temporary/xyu1/scratch/skywater-pdk-libs-sky130_fd_pr/models/r+c/res_typical__cap_typical__lin.spice
.include /home/idies/workspace/Temporary/xyu1/scratch/skywater-pdk-libs-sky130_fd_pr/models/corners/tt/specialized_cells.spice
.model DIDEAL D   is=1e-14 n=1
.options reltol=1e-3 itl1=500 itl2=100

* Sources
VVDD VDD 0 1.8
VLABEL_NET_0 LABEL_NET_0 0 DC 0.9 AC 1

* Circuit
XMN4 N15 N3 N4 GND sky130_fd_pr__nfet_01v8 l=0.5 w=5
XMP13 N11 BIAS5 VDD VDD sky130_fd_pr__pfet_01v8 l=0.5 w=5
XMN15 N11 N14 N0 GND sky130_fd_pr__nfet_01v8 l=0.5 w=5
XMP9 N2 BIAS4 VDD VDD sky130_fd_pr__pfet_01v8 l=0.5 w=5
XMP5 N15 LABEL_NET_0 N2 VDD sky130_fd_pr__pfet_01v8 l=0.5 w=5
XMP6 N17 N9 N5 VDD sky130_fd_pr__pfet_01v8 l=0.5 w=5
XMP10 N5 BIAS4 VDD VDD sky130_fd_pr__pfet_01v8 l=0.5 w=5
XMN3 N17 N7 N6 GND sky130_fd_pr__nfet_01v8 l=0.5 w=5
XMN16 N8 N15 N0 GND sky130_fd_pr__nfet_01v8 l=0.5 w=5
XMN1 N6 VI_PLUS N1 GND sky130_fd_pr__nfet_01v8 l=0.5 w=5
XMP14 N8 BIAS5 VDD VDD sky130_fd_pr__pfet_01v8 l=0.5 w=5
XMNT2 N0 STAGE2_CMFB GND GND sky130_fd_pr__nfet_01v8 l=0.5 w=5
XMN2 N4 VI_MINUS N1 GND sky130_fd_pr__nfet_01v8 l=0.5 w=5
XMNT1 N1 STAGE1_CMFB GND GND sky130_fd_pr__nfet_01v8 l=0.5 w=5
R1 N13 N15 10k
R2 N12 N14 10k
C1 N13 N13 1p
C2 N12 N12 1p

.control
set filetype=ascii

op
let power_dc = abs(i(VVDD)) * 1.8
print power_dc

ac dec 100 1 10g
let gain_STAGE2_CMFB = db(vm(STAGE2_CMFB))
let gain_BIAS4 = db(vm(BIAS4))
let gain_N1 = db(vm(N1))
let gain_N7 = db(vm(N7))
let gain_N17 = db(vm(N17))
meas ac max_gain_STAGE2_CMFB MAX gain_STAGE2_CMFB
meas ac max_gain_BIAS4 MAX gain_BIAS4
meas ac max_gain_N1 MAX gain_N1
meas ac max_gain_N7 MAX gain_N7
meas ac max_gain_N17 MAX gain_N17

* Use first probe node for standard metrics
let gain_db = db(vm(STAGE2_CMFB))
meas ac dc_gain_db FIND gain_db AT=1
meas ac ugbw WHEN gain_db=0 CROSS=1
let vout_dc = v(STAGE2_CMFB)

print dc_gain_db ugbw vout_dc gain_STAGE2_CMFB gain_BIAS4 gain_N1 gain_N7 gain_N17

quit
.endc

.end
