* Testcase 000264 — Full Analysis (sky130 tt corner)
* SKY130 model header — replaces the ideal level-1 .model cards
* Ships with the demo; the paths point at the local sky130 PDK checkout.
* NOTE: libs.tech/ngspice/all.spice sets ".option scale=1.0u", so every
* instance L/W below is written in microns WITHOUT a "u" suffix.
.param mc_mm_switch=0
.param mc_pr_switch=0
.include /home/idies/workspace/Temporary/xyu1/scratch/skywater-pdk-libs-sky130_fd_pr/models/corners/tt.spice
.include /home/idies/workspace/Temporary/xyu1/scratch/skywater-pdk-libs-sky130_fd_pr/models/r+c/res_typical__cap_typical.spice
.include /home/idies/workspace/Temporary/xyu1/scratch/skywater-pdk-libs-sky130_fd_pr/models/r+c/res_typical__cap_typical__lin.spice
.include /home/idies/workspace/Temporary/xyu1/scratch/skywater-pdk-libs-sky130_fd_pr/models/corners/tt/specialized_cells.spice
.model DIDEAL D   is=1e-14 n=1
.options reltol=1e-3 itl1=500 itl2=100

* Sources
VVDD VDD 0 1.8

* Circuit
XM14 NET_A NUITP VDD VDD sky130_fd_pr__pfet_01v8 l=0.5 w=5
XM8 NET_A NUITP GND GND sky130_fd_pr__nfet_01v8 l=0.5 w=5
XM3 NET_C NUITN VDD VDD sky130_fd_pr__pfet_01v8 l=0.5 w=5
XM10 NET_C NUITN GND GND sky130_fd_pr__nfet_01v8 l=0.5 w=5
XM13 NET_B NET_A VDD VDD sky130_fd_pr__pfet_01v8 l=0.5 w=5
XM18 NET_B NET_C VDD VDD sky130_fd_pr__pfet_01v8 l=0.5 w=5
XM2 NET_B NET_C NET_M1_D GND sky130_fd_pr__nfet_01v8 l=0.5 w=5
XM1 NET_M1_D NET_A GND GND sky130_fd_pr__nfet_01v8 l=0.5 w=5
XM19 NET_H NET_C VDD VDD sky130_fd_pr__pfet_01v8 l=0.5 w=5
XM22 NET_H NET_A VDD VDD sky130_fd_pr__pfet_01v8 l=0.5 w=5
XM9 NET_H NET_A NET_M6_D GND sky130_fd_pr__nfet_01v8 l=0.5 w=5
XM6 NET_M6_D NET_C GND GND sky130_fd_pr__nfet_01v8 l=0.5 w=5
XM20 NET_D NET_B VDD VDD sky130_fd_pr__pfet_01v8 l=0.5 w=5
XM7 NET_D NET_B GND GND sky130_fd_pr__nfet_01v8 l=0.5 w=5
XM15 NET_I NET_H VDD VDD sky130_fd_pr__pfet_01v8 l=0.5 w=5
XM4 NET_I NET_H GND GND sky130_fd_pr__nfet_01v8 l=0.5 w=5
I1 NET_TAIL GND 1u
XM11 NET_F NET_D NET_TAIL GND sky130_fd_pr__nfet_01v8 l=0.5 w=5
XM5 NET_G NET_I NET_TAIL GND sky130_fd_pr__nfet_01v8 l=0.5 w=5
XM16 NET_F NET_G VDD VDD sky130_fd_pr__pfet_01v8 l=0.5 w=5
XM17 NET_G NET_F VDD VDD sky130_fd_pr__pfet_01v8 l=0.5 w=5
XM12 NET_F NET_F VDD VDD sky130_fd_pr__pfet_01v8 l=0.5 w=5
XM21 NET_G NET_G VDD VDD sky130_fd_pr__pfet_01v8 l=0.5 w=5

.control
set filetype=ascii

op
let vdd_current = abs(i(VVDD))
let power_dc = vdd_current * 1.8
print power_dc

print all

let vout_dc = v(NET_C)
print vout_dc
let vout_dc = v(NET_C)
print vout_dc
quit
.endc

.end
