* Testcase 000228 — Full Analysis (sky130 tt corner)
* SKY130 model header — replaces the ideal level-1 .model cards
* Ships with the demo; the paths point at the local sky130 PDK checkout.
* NOTE: libs.tech/ngspice/all.spice sets ".option scale=1.0u", so every
* instance L/W below is written in microns WITHOUT a "u" suffix.
.param mc_mm_switch=0
.param mc_pr_switch=0
.include /home/idies/workspace/Temporary/xyu1/scratch/skywater-pdk-libs-sky130_fd_pr/models/corners/tt.spice
.include /home/idies/workspace/Temporary/xyu1/scratch/skywater-pdk-libs-sky130_fd_pr/models/r+c/res_typical__cap_typical.spice
.include /home/idies/workspace/Temporary/xyu1/scratch/skywater-pdk-libs-sky130_fd_pr/models/r+c/res_typical__cap_typical__lin.spice
.include /home/idies/workspace/Temporary/xyu1/scratch/skywater-pdk-libs-sky130_fd_pr/models/corners/tt/specialized_cells.spice
.model DIDEAL D   is=1e-14 n=1
.options reltol=1e-3 itl1=500 itl2=100

* Sources
VVDD VDD 0 1.8

* Circuit
XM1 VCO_SUPPLY_V N4 FULL_VDD VDD sky130_fd_pr__pfet_01v8 l=0.5 w=5
XM2 N7 N7 FULL_VDD VDD sky130_fd_pr__pfet_01v8 l=0.5 w=5
XM3 N7 VCO_SUPPLY_V N1 GND sky130_fd_pr__nfet_01v8 l=0.5 w=5
XM4 N4 N5 N1 GND sky130_fd_pr__nfet_01v8 l=0.5 w=5
XM5 N6 N5 GND GND sky130_fd_pr__nfet_01v8 l=0.5 w=5
XM6 N3 N3 GND GND sky130_fd_pr__nfet_01v8 l=0.5 w=5
XM7 N4 N7 FULL_VDD VDD sky130_fd_pr__pfet_01v8 l=0.5 w=5
XM8 N3 N6 FULL_VDD VDD sky130_fd_pr__pfet_01v8 l=0.5 w=5
XM9 N1 N3 GND GND sky130_fd_pr__nfet_01v8 l=0.5 w=5
XM10 N6 N6 FULL_VDD VDD sky130_fd_pr__pfet_01v8 l=0.5 w=5
C1 VCO_SUPPLY_V GND 1p
XM11 GND GND N5 VDD sky130_fd_pr__pfet_01v8 l=0.5 w=5
XM12 GND N5 GND GND sky130_fd_pr__nfet_01v8 l=0.5 w=5

.control
set filetype=ascii

op
let vdd_current = abs(i(VVDD))
let power_dc = vdd_current * 1.8
print power_dc

ac dec 100 1 10g
let vout_mag = vm(VCO_SUPPLY_V)
let gain_db = db(vout_mag)
let dc_gain_db = gain_db[0]
print dc_gain_db

if dc_gain_db > 0
    meas ac ugbw WHEN gain_db=0 CROSS=1
end

quit
.endc

.end
