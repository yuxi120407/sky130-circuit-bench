* Testcase 001214 — Full Analysis (sky130 tt corner)
* SKY130 model header — replaces the ideal level-1 .model cards
* Ships with the demo; the paths point at the local sky130 PDK checkout.
* NOTE: libs.tech/ngspice/all.spice sets ".option scale=1.0u", so every
* instance L/W below is written in microns WITHOUT a "u" suffix.
.param mc_mm_switch=0
.param mc_pr_switch=0
.include /home/idies/workspace/Temporary/xyu1/scratch/skywater-pdk-libs-sky130_fd_pr/models/corners/tt.spice
.include /home/idies/workspace/Temporary/xyu1/scratch/skywater-pdk-libs-sky130_fd_pr/models/r+c/res_typical__cap_typical.spice
.include /home/idies/workspace/Temporary/xyu1/scratch/skywater-pdk-libs-sky130_fd_pr/models/r+c/res_typical__cap_typical__lin.spice
.include /home/idies/workspace/Temporary/xyu1/scratch/skywater-pdk-libs-sky130_fd_pr/models/corners/tt/specialized_cells.spice
.model DIDEAL D   is=1e-14 n=1
.options reltol=1e-3 itl1=500 itl2=100

* Sources
VVDD VDD 0 1.8
VLABEL_NET_0 LABEL_NET_0 0 DC 0.9 AC 0.5

* Circuit
XM1 N8 GND GND GND sky130_fd_pr__nfet_01v8 l=0.5 w=5
XM2 GND N1 GND GND sky130_fd_pr__nfet_01v8 l=0.5 w=5
XM3 N0 N10 GND GND sky130_fd_pr__nfet_01v8 l=0.5 w=5
XM4 N9 N2 VDD VDD sky130_fd_pr__pfet_01v8 l=0.5 w=5
XM5 N10 N11 GND GND sky130_fd_pr__nfet_01v8 l=0.5 w=5
XM6 N4 N4 N9 VDD sky130_fd_pr__pfet_01v8 l=0.5 w=5
XM7 GND N9 N2 VDD sky130_fd_pr__pfet_01v8 l=0.5 w=5
XM8 N1 LABEL_NET_0 GND GND sky130_fd_pr__nfet_01v8 l=0.5 w=5
XM9 VDD GND N1 GND sky130_fd_pr__nfet_01v8 l=0.5 w=5
XM10 N10 N5 VDD VDD sky130_fd_pr__pfet_01v8 l=0.5 w=5
XM11 N1 N3 VDD VDD sky130_fd_pr__pfet_01v8 l=0.5 w=5
XM12 N0 N6 VDD VDD sky130_fd_pr__pfet_01v8 l=0.5 w=5
XM13 N8 N7 VDD VDD sky130_fd_pr__pfet_01v8 l=0.5 w=5
XM14 GND GND N1 VDD sky130_fd_pr__pfet_01v8 l=0.5 w=5
XM15 GND N7 VDD VDD sky130_fd_pr__pfet_01v8 l=0.5 w=5
XM16 N4 N10 N11 GND sky130_fd_pr__nfet_01v8 l=0.5 w=5
XM17 N11 N10 GND GND sky130_fd_pr__nfet_01v8 l=0.5 w=5
XM18 N2 N4 N3 GND sky130_fd_pr__nfet_01v8 l=0.5 w=5

.control
set filetype=ascii

op
let power_dc = abs(i(VVDD)) * 1.8
print power_dc

ac dec 100 1 10g
let vout_mag = vm(N1)
let gain_db = db(vout_mag)
let dc_gain_db = gain_db[0]
print dc_gain_db

if dc_gain_db > 0
    meas ac ugbw WHEN gain_db=0 CROSS=1
    print ugbw
end

quit
.endc

.end
