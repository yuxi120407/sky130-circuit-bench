* Testcase 000455 — Full Analysis (sky130 tt corner)
* SKY130 model header — replaces the ideal level-1 .model cards
* Ships with the demo; the paths point at the local sky130 PDK checkout.
* NOTE: libs.tech/ngspice/all.spice sets ".option scale=1.0u", so every
* instance L/W below is written in microns WITHOUT a "u" suffix.
.param mc_mm_switch=0
.param mc_pr_switch=0
.include /home/idies/workspace/Temporary/xyu1/scratch/skywater-pdk-libs-sky130_fd_pr/models/corners/tt.spice
.include /home/idies/workspace/Temporary/xyu1/scratch/skywater-pdk-libs-sky130_fd_pr/models/r+c/res_typical__cap_typical.spice
.include /home/idies/workspace/Temporary/xyu1/scratch/skywater-pdk-libs-sky130_fd_pr/models/r+c/res_typical__cap_typical__lin.spice
.include /home/idies/workspace/Temporary/xyu1/scratch/skywater-pdk-libs-sky130_fd_pr/models/corners/tt/specialized_cells.spice
.model DIDEAL D   is=1e-14 n=1
.options reltol=1e-3 itl1=500 itl2=100

* Sources
VVDD VDD 0 1.8

* Circuit
XM4 N0 N3 N9 VDD sky130_fd_pr__pfet_01v8 l=0.5 w=5
XM3 BIAS_N BIAS_N N8 GND sky130_fd_pr__nfet_01v8 l=0.5 w=5
C1 N0 TO_ANT 1p
XM8 N2 N3 VDD VDD sky130_fd_pr__pfet_01v8 l=0.5 w=5
C2 N1 N8 1p
XM1 N1 N0 N1 VDD sky130_fd_pr__pfet_01v8 l=0.5 w=5
XM7 N7 N2 N9 VDD sky130_fd_pr__pfet_01v8 l=0.5 w=5
XM2 N9 BIAS_P VDD VDD sky130_fd_pr__pfet_01v8 l=0.5 w=5
XM9 N2 N3 N8 GND sky130_fd_pr__nfet_01v8 l=0.5 w=5
XM11 N6 FROM_LOGIC N8 GND sky130_fd_pr__nfet_01v8 l=0.5 w=5
XM6 N0 N3 BIAS_N GND sky130_fd_pr__nfet_01v8 l=0.5 w=5
XM5 N7 N2 BIAS_N GND sky130_fd_pr__nfet_01v8 l=0.5 w=5
XM10 N6 FROM_LOGIC VDD VDD sky130_fd_pr__pfet_01v8 l=0.5 w=5

.control
set filetype=ascii

op
let vdd_current = abs(i(VVDD))
let power_dc = vdd_current * 1.8
print power_dc

print all

let vout_dc = v(BIAS_N)
print vout_dc
let vout_dc = v(BIAS_N)
print vout_dc
quit
.endc

.end
