* Testcase 000430 — Full Analysis (sky130 tt corner)
* SKY130 model header — replaces the ideal level-1 .model cards
* Ships with the demo; the paths point at the local sky130 PDK checkout.
* NOTE: libs.tech/ngspice/all.spice sets ".option scale=1.0u", so every
* instance L/W below is written in microns WITHOUT a "u" suffix.
.param mc_mm_switch=0
.param mc_pr_switch=0
.include /home/idies/workspace/Temporary/xyu1/scratch/skywater-pdk-libs-sky130_fd_pr/models/corners/tt.spice
.include /home/idies/workspace/Temporary/xyu1/scratch/skywater-pdk-libs-sky130_fd_pr/models/r+c/res_typical__cap_typical.spice
.include /home/idies/workspace/Temporary/xyu1/scratch/skywater-pdk-libs-sky130_fd_pr/models/r+c/res_typical__cap_typical__lin.spice
.include /home/idies/workspace/Temporary/xyu1/scratch/skywater-pdk-libs-sky130_fd_pr/models/corners/tt/specialized_cells.spice
.model DIDEAL D   is=1e-14 n=1
.options reltol=1e-3 itl1=500 itl2=100

* Sources
VVDD VDD 0 1.8

* Circuit
I_SS1_2 VDD N7 1u
I_SS2 VDD V_VR 1u
I_SS1 VDD N4 1u
XM13 V_VR V_VR GND GND sky130_fd_pr__nfet_01v8 l=0.5 w=5
XM8 V_VP V_VP GND GND sky130_fd_pr__nfet_01v8 l=0.5 w=5
XM7 V_VP V_GP VDD VDD sky130_fd_pr__pfet_01v8 l=0.5 w=5
XM11 V_VN N5 VDD VDD sky130_fd_pr__pfet_01v8 l=0.5 w=5
XM6 I_X V_VR N7 VDD sky130_fd_pr__pfet_01v8 l=0.5 w=5
XM2 I_Z N9 N4 VDD sky130_fd_pr__pfet_01v8 l=0.5 w=5
XM10 N5 N5 VDD VDD sky130_fd_pr__pfet_01v8 l=0.5 w=5
XM1 I_X V_VP N4 VDD sky130_fd_pr__pfet_01v8 l=0.5 w=5
XM4 I_Y V_VN N7 VDD sky130_fd_pr__pfet_01v8 l=0.5 w=5
XM3 I_Y V_VR N4 VDD sky130_fd_pr__pfet_01v8 l=0.5 w=5
XM12 V_VN V_VN V_SS GND sky130_fd_pr__nfet_01v8 l=0.5 w=5
XM9 N5 V_GN V_SS GND sky130_fd_pr__nfet_01v8 l=0.5 w=5
XM5 I_Z V_VN N7 VDD sky130_fd_pr__pfet_01v8 l=0.5 w=5

.control
set filetype=ascii

op
let vdd_current = abs(i(VVDD))
let power_dc = vdd_current * 1.8
print power_dc

print all

let vout_dc = v(V_VN)
print vout_dc
let vout_dc = v(N5)
print vout_dc
quit
.endc

.end
