* Testcase 001111 — Full Analysis (sky130 tt corner)
* SKY130 model header — replaces the ideal level-1 .model cards
* Ships with the demo; the paths point at the local sky130 PDK checkout.
* NOTE: libs.tech/ngspice/all.spice sets ".option scale=1.0u", so every
* instance L/W below is written in microns WITHOUT a "u" suffix.
.param mc_mm_switch=0
.param mc_pr_switch=0
.include /home/idies/workspace/Temporary/xyu1/scratch/skywater-pdk-libs-sky130_fd_pr/models/corners/tt.spice
.include /home/idies/workspace/Temporary/xyu1/scratch/skywater-pdk-libs-sky130_fd_pr/models/r+c/res_typical__cap_typical.spice
.include /home/idies/workspace/Temporary/xyu1/scratch/skywater-pdk-libs-sky130_fd_pr/models/r+c/res_typical__cap_typical__lin.spice
.include /home/idies/workspace/Temporary/xyu1/scratch/skywater-pdk-libs-sky130_fd_pr/models/corners/tt/specialized_cells.spice
.model DIDEAL D   is=1e-14 n=1
.options reltol=1e-3 itl1=500 itl2=100

* Sources
VVDD VDD 0 1.8
VLABEL_NET_0 LABEL_NET_0 0 DC 0.9 AC 0.5
VLABEL_NET_1 LABEL_NET_1 0 DC 0.9 AC -0.5
VLABEL_NET_2 LABEL_NET_2 0 0.9
VLABEL_NET_3 LABEL_NET_3 0 0.9
VLABEL_NET_4 LABEL_NET_4 0 0.9
VLABEL_NET_5 LABEL_NET_5 0 0.9
VLABEL_NET_6 LABEL_NET_6 0 0.9
VLABEL_NET_7 LABEL_NET_7 0 0.9

* Circuit
XM1 N13 LABEL_NET_0 N5 VDD sky130_fd_pr__pfet_01v8 l=0.5 w=5
XQ1 N6 LABEL_NET_1 N19 0 sky130_fd_pr__npn_05v5_W1p00L1p00
XQ2 N23 LABEL_NET_2 N21 0 sky130_fd_pr__npn_05v5_W1p00L1p00
XM2 N2 N2 N5 VDD sky130_fd_pr__pfet_01v8 l=0.5 w=5
XQ3 N6 LABEL_NET_3 N17 0 sky130_fd_pr__npn_05v5_W1p00L1p00
XM3 N12 LABEL_NET_0 N5 VDD sky130_fd_pr__pfet_01v8 l=0.5 w=5
XQ4 N1 LABEL_NET_4 N17 0 sky130_fd_pr__npn_05v5_W1p00L1p00
XQ5 N17 N0 N20 0 sky130_fd_pr__npn_05v5_W1p00L1p00
XM4 N1 N11 N12 VDD sky130_fd_pr__pfet_01v8 l=0.5 w=5
XQ6 N19 N14 N22 0 sky130_fd_pr__npn_05v5_W1p00L1p00
XM5 N8 LABEL_NET_0 N5 VDD sky130_fd_pr__pfet_01v8 l=0.5 w=5
XM6 N3 N11 N13 VDD sky130_fd_pr__pfet_01v8 l=0.5 w=5
XM7 N9 N3 N23 GND sky130_fd_pr__nfet_01v8 l=0.5 w=5
XM8 N10 LABEL_NET_0 N5 VDD sky130_fd_pr__pfet_01v8 l=0.5 w=5
XM9 N9 N9 N2 VDD sky130_fd_pr__pfet_01v8 l=0.5 w=5
C1 N3 N4 1p
XQ7 N1 LABEL_NET_5 N19 0 sky130_fd_pr__npn_05v5_W1p00L1p00
XQ8 N3 N3 N24 0 sky130_fd_pr__npn_05v5_W1p00L1p00
XQ9 N23 LABEL_NET_6 N15 0 sky130_fd_pr__npn_05v5_W1p00L1p00
XQ10 N3 N3 N24 0 sky130_fd_pr__npn_05v5_W1p00L1p00
C2 N4 N6 1p
XQ11 N24 N14 N16 0 sky130_fd_pr__npn_05v5_W1p00L1p00
C3 N1 N4 1p
R1 N4 N21 10k
XM10 N6 N11 N10 VDD sky130_fd_pr__pfet_01v8 l=0.5 w=5
R2 N4 N15 10k
R3 N4 N16 10k
R4 N4 N22 10k
R5 N4 N20 10k
XM11 N7 LABEL_NET_7 N23 GND sky130_fd_pr__nfet_01v8 l=0.5 w=5
XM12 N7 N11 N8 VDD sky130_fd_pr__pfet_01v8 l=0.5 w=5

.control
set filetype=ascii

op
let power_dc = abs(i(VVDD)) * 1.8
print power_dc

ac dec 100 1 10g
let vout_mag = vm(N1)
let gain_db = db(vout_mag)
let dc_gain_db = gain_db[0]
print dc_gain_db

if dc_gain_db > 0
    meas ac ugbw WHEN gain_db=0 CROSS=1
    print ugbw
end

quit
.endc

.end
