* Testcase 000366 — Full Analysis (sky130 tt corner)
* SKY130 model header — replaces the ideal level-1 .model cards
* Ships with the demo; the paths point at the local sky130 PDK checkout.
* NOTE: libs.tech/ngspice/all.spice sets ".option scale=1.0u", so every
* instance L/W below is written in microns WITHOUT a "u" suffix.
.param mc_mm_switch=0
.param mc_pr_switch=0
.include /home/idies/workspace/Temporary/xyu1/scratch/skywater-pdk-libs-sky130_fd_pr/models/corners/tt.spice
.include /home/idies/workspace/Temporary/xyu1/scratch/skywater-pdk-libs-sky130_fd_pr/models/r+c/res_typical__cap_typical.spice
.include /home/idies/workspace/Temporary/xyu1/scratch/skywater-pdk-libs-sky130_fd_pr/models/r+c/res_typical__cap_typical__lin.spice
.include /home/idies/workspace/Temporary/xyu1/scratch/skywater-pdk-libs-sky130_fd_pr/models/corners/tt/specialized_cells.spice
.model DIDEAL D   is=1e-14 n=1
.options reltol=1e-3 itl1=500 itl2=100

* Sources
VVDD VDD 0 1.8
VVBP VBP 0 DC 0.9900000000000001 AC 0.5

* Circuit
XM8 N_M2D N_PG VDD VDD sky130_fd_pr__pfet_01v8 l=0.5 w=5
XM4 B VBP N_M2D VDD sky130_fd_pr__pfet_01v8 l=0.5 w=5
XM1 N_M5D N_PG VDD VDD sky130_fd_pr__pfet_01v8 l=0.5 w=5
XM5 A VBP N_M5D VDD sky130_fd_pr__pfet_01v8 l=0.5 w=5
XM2 N_PG N_PG VDD VDD sky130_fd_pr__pfet_01v8 l=0.5 w=5
XM3 VBP VBP N_PG VDD sky130_fd_pr__pfet_01v8 l=0.5 w=5
XM9 B B N_M3S GND sky130_fd_pr__nfet_01v8 l=0.5 w=5
XM10 N_M3S N_NG GND GND sky130_fd_pr__nfet_01v8 l=0.5 w=5
XM7 A B N_NG GND sky130_fd_pr__nfet_01v8 l=0.5 w=5
XM6 N_NG N_NG GND GND sky130_fd_pr__nfet_01v8 l=0.5 w=5
I1 VBP GND 1u
C2 A B 10p
C3 B GND 1p
C1 A GND 1p

.control
set filetype=ascii

op
let vdd_current = abs(i(VVDD))
let power_dc = vdd_current * 1.8
print power_dc

ac dec 100 1 10g
let vout_mag = vm(B)
let gain_db = db(vout_mag)
let dc_gain_db = gain_db[0]
print dc_gain_db

if dc_gain_db > 0
    meas ac ugbw WHEN gain_db=0 CROSS=1
end

quit
.endc

.end
