* Testcase 000475 — Full Analysis (sky130 tt corner)
* SKY130 model header — replaces the ideal level-1 .model cards
* Ships with the demo; the paths point at the local sky130 PDK checkout.
* NOTE: libs.tech/ngspice/all.spice sets ".option scale=1.0u", so every
* instance L/W below is written in microns WITHOUT a "u" suffix.
.param mc_mm_switch=0
.param mc_pr_switch=0
.include /home/idies/workspace/Temporary/xyu1/scratch/skywater-pdk-libs-sky130_fd_pr/models/corners/tt.spice
.include /home/idies/workspace/Temporary/xyu1/scratch/skywater-pdk-libs-sky130_fd_pr/models/r+c/res_typical__cap_typical.spice
.include /home/idies/workspace/Temporary/xyu1/scratch/skywater-pdk-libs-sky130_fd_pr/models/r+c/res_typical__cap_typical__lin.spice
.include /home/idies/workspace/Temporary/xyu1/scratch/skywater-pdk-libs-sky130_fd_pr/models/corners/tt/specialized_cells.spice
.model DIDEAL D   is=1e-14 n=1
.options reltol=1e-3 itl1=500 itl2=100

* Sources
VVBIAS_B VBIAS_B 0 DC 0.54 AC 1
VVINp VINp 0 DC 0.9 AC 1 SIN(0.9 0.1 1MEG 0 0)
VVINn VINn 0 DC 0.9 AC 1 SIN(0.9 0.1 1MEG 0 0)

* Circuit
XM1 N0 VBIAS_B GND GND sky130_fd_pr__nfet_01v8 l=0.5 w=5
XM2 IOUTn VINp N0 GND sky130_fd_pr__nfet_01v8 l=0.5 w=5
XM3 IOUTp VINn N0 GND sky130_fd_pr__nfet_01v8 l=0.5 w=5

.control
set filetype=ascii

op
let power_dc = 0
print power_dc

ac dec 100 1 10g
let gain_IOUTn = db(vm(IOUTn))
let gain_IOUTp = db(vm(IOUTp))
let gain_N0 = db(vm(N0))
meas ac max_gain_IOUTn MAX gain_IOUTn
meas ac max_gain_IOUTp MAX gain_IOUTp
meas ac max_gain_N0 MAX gain_N0

* Use first probe node for standard metrics
let gain_db = db(vm(IOUTn))
meas ac dc_gain_db FIND gain_db AT=1
meas ac ugbw WHEN gain_db=0 CROSS=1
let vout_dc = v(IOUTn)

print dc_gain_db ugbw vout_dc gain_IOUTn gain_IOUTp gain_N0

quit
.endc

.end
