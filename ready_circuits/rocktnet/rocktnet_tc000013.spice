* Testcase 000013 — Full Analysis (sky130 tt corner)
* SKY130 model header — replaces the ideal level-1 .model cards
* Ships with the demo; the paths point at the local sky130 PDK checkout.
* NOTE: libs.tech/ngspice/all.spice sets ".option scale=1.0u", so every
* instance L/W below is written in microns WITHOUT a "u" suffix.
.param mc_mm_switch=0
.param mc_pr_switch=0
.include /home/idies/workspace/Temporary/xyu1/scratch/skywater-pdk-libs-sky130_fd_pr/models/corners/tt.spice
.include /home/idies/workspace/Temporary/xyu1/scratch/skywater-pdk-libs-sky130_fd_pr/models/r+c/res_typical__cap_typical.spice
.include /home/idies/workspace/Temporary/xyu1/scratch/skywater-pdk-libs-sky130_fd_pr/models/r+c/res_typical__cap_typical__lin.spice
.include /home/idies/workspace/Temporary/xyu1/scratch/skywater-pdk-libs-sky130_fd_pr/models/corners/tt/specialized_cells.spice
.model DIDEAL D   is=1e-14 n=1
.options reltol=1e-3 itl1=500 itl2=100

* Sources
VVDD VDD 0 1.8
VLABEL_NET_0 LABEL_NET_0 0 DC 0.9 AC 0.5
VLABEL_NET_4 LABEL_NET_4 0 DC 0.9 AC -0.5
VLABEL_NET_5 LABEL_NET_5 0 0.9
VLABEL_NET_6 LABEL_NET_6 0 0.9
VLABEL_NET_7 LABEL_NET_7 0 0.9
VLABEL_NET_8 LABEL_NET_8 0 0.9
VLABEL_NET_9 LABEL_NET_9 0 0.9
VLABEL_NET_10 LABEL_NET_10 0 0.9
VLABEL_NET_11 LABEL_NET_11 0 0.9

* Circuit
XM1 N3 N13 VDD VDD sky130_fd_pr__pfet_01v8 l=0.5 w=5
XM2 N2 N12 GND GND sky130_fd_pr__nfet_01v8 l=0.5 w=5
XM3 VDD LABEL_NET_0 N6 GND sky130_fd_pr__nfet_01v8 l=0.5 w=5
XM4 N3 N13 VDD VDD sky130_fd_pr__pfet_01v8 l=0.5 w=5
XM5 N10 N12 GND GND sky130_fd_pr__nfet_01v8 l=0.5 w=5
XM6 N0 N8 GND GND sky130_fd_pr__nfet_01v8 l=0.5 w=5
XM7 N5 LABEL_NET_4 GND GND sky130_fd_pr__nfet_01v8 l=0.5 w=5
XM8 N11 N14 N2 GND sky130_fd_pr__nfet_01v8 l=0.5 w=5
XM9 N1 N8 GND GND sky130_fd_pr__nfet_01v8 l=0.5 w=5
XM10 N6 LABEL_NET_5 GND GND sky130_fd_pr__nfet_01v8 l=0.5 w=5
XM11 N4 VDD N3 VDD sky130_fd_pr__pfet_01v8 l=0.5 w=5
XM12 N11 LABEL_NET_6 N3 VDD sky130_fd_pr__pfet_01v8 l=0.5 w=5
R1 N0 N1 10k
XM13 N7 LABEL_NET_7 N3 VDD sky130_fd_pr__pfet_01v8 l=0.5 w=5
R2 N7 N11 10k
XM14 N4 LABEL_NET_8 N3 VDD sky130_fd_pr__pfet_01v8 l=0.5 w=5
XM15 N4 LABEL_NET_9 N6 GND sky130_fd_pr__nfet_01v8 l=0.5 w=5
XM16 N5 LABEL_NET_10 N3 VDD sky130_fd_pr__pfet_01v8 l=0.5 w=5
XM17 N7 N9 N10 GND sky130_fd_pr__nfet_01v8 l=0.5 w=5
XM18 N1 N9 N3 VDD sky130_fd_pr__pfet_01v8 l=0.5 w=5
XM19 N3 LABEL_NET_11 N0 GND sky130_fd_pr__nfet_01v8 l=0.5 w=5
C1 N3 GND 1p
C2 N3 N3 1p
XM20 N3 N3 N5 GND sky130_fd_pr__nfet_01v8 l=0.5 w=5

.control
set filetype=ascii

op
let vdd_current = abs(i(VVDD))
let power_dc = vdd_current * 1.8
print power_dc

ac dec 100 1 10g
let vout_mag = vm(N3)
let gain_db = db(vout_mag)
let dc_gain_db = gain_db[0]
print dc_gain_db

if dc_gain_db > 0
    meas ac ugbw WHEN gain_db=0 CROSS=1
end

quit
.endc

.end
