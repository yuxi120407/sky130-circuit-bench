* Testcase 000718 — Full Analysis (sky130 tt corner)
* SKY130 model header — replaces the ideal level-1 .model cards
* Ships with the demo; the paths point at the local sky130 PDK checkout.
* NOTE: libs.tech/ngspice/all.spice sets ".option scale=1.0u", so every
* instance L/W below is written in microns WITHOUT a "u" suffix.
.param mc_mm_switch=0
.param mc_pr_switch=0
.include /home/idies/workspace/Temporary/xyu1/scratch/skywater-pdk-libs-sky130_fd_pr/models/corners/tt.spice
.include /home/idies/workspace/Temporary/xyu1/scratch/skywater-pdk-libs-sky130_fd_pr/models/r+c/res_typical__cap_typical.spice
.include /home/idies/workspace/Temporary/xyu1/scratch/skywater-pdk-libs-sky130_fd_pr/models/r+c/res_typical__cap_typical__lin.spice
.include /home/idies/workspace/Temporary/xyu1/scratch/skywater-pdk-libs-sky130_fd_pr/models/corners/tt/specialized_cells.spice
.model DIDEAL D   is=1e-14 n=1
.options reltol=1e-2 abstol=1e-10 vntol=1e-4 itl1=1000 itl2=200 itl4=100
.options gmin=1e-10 method=gear

* Sources
VIN IN 0 DC 0.9 AC 1 SIN(0.9 0.1 1MEG 0 0)

* Circuit
XQ4 OUTP VCC N13 0 sky130_fd_pr__npn_05v5_W1p00L1p00
CBYP3 N7 GND 1p
XQ2 N13 N0 N8 0 sky130_fd_pr__npn_05v5_W1p00L1p00
TL3 N5 N6 10k
R2 N0 BIAS1 10k
R3 N11 GND 10k
R1 N1 BIAS1 10k
R4 N7 BIAS2 10k
TL4 N6 N8 10k
C2 N0 GND 1p
CBYP2 BIAS1 GND 1p
XQ3 OUTN VCC N2 0 sky130_fd_pr__npn_05v5_W1p00L1p00
XQ5 N6 N7 N11 0 sky130_fd_pr__npn_05v5_W1p00L1p00
XQ1 N2 N1 N5 0 sky130_fd_pr__npn_05v5_W1p00L1p00
C1 N1 N9 1p
L1 N9 IN 10n
CBYP1 VCC GND 1p
TL1 VCC OUTN 1u
TL5 IN IN 10k
TL2 VCC OUTP 10k

.control
set filetype=ascii

op
let power_dc = abs(i(VIN)) * 1.8
print power_dc
let dc_voltage = v(BIAS1)
print dc_voltage
print all

quit
.endc

.end
