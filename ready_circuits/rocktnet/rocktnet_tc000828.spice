* Testcase 000828 — Full Analysis (sky130 tt corner)
* SKY130 model header — replaces the ideal level-1 .model cards
* Ships with the demo; the paths point at the local sky130 PDK checkout.
* NOTE: libs.tech/ngspice/all.spice sets ".option scale=1.0u", so every
* instance L/W below is written in microns WITHOUT a "u" suffix.
.param mc_mm_switch=0
.param mc_pr_switch=0
.include /home/idies/workspace/Temporary/xyu1/scratch/skywater-pdk-libs-sky130_fd_pr/models/corners/tt.spice
.include /home/idies/workspace/Temporary/xyu1/scratch/skywater-pdk-libs-sky130_fd_pr/models/r+c/res_typical__cap_typical.spice
.include /home/idies/workspace/Temporary/xyu1/scratch/skywater-pdk-libs-sky130_fd_pr/models/r+c/res_typical__cap_typical__lin.spice
.include /home/idies/workspace/Temporary/xyu1/scratch/skywater-pdk-libs-sky130_fd_pr/models/corners/tt/specialized_cells.spice
.model DIDEAL D   is=1e-14 n=1
.options reltol=1e-3 itl1=500 itl2=100

* Sources
VVDD VDD 0 1.8

* Circuit
I1 VDD N5 1u
I2 Q_OUT N2 1u
I3 VDD N4 1u
I4 Q_OUT N10 1u
XM1 N10 BIAS2 N11 GND sky130_fd_pr__nfet_01v8 l=0.5 w=5
XM3 I_OUT I_LO N5 GND sky130_fd_pr__nfet_01v8 l=0.5 w=5
XM2 I_OUT N3 N4 GND sky130_fd_pr__nfet_01v8 l=0.5 w=5
XM4 Q_OUT VDD N2 GND sky130_fd_pr__nfet_01v8 l=0.5 w=5
XM5 N2 N8 N11 GND sky130_fd_pr__nfet_01v8 l=0.5 w=5
XM6 Q_OUT Q_LO N2 GND sky130_fd_pr__nfet_01v8 l=0.5 w=5
XM7 N11 N15 GND GND sky130_fd_pr__nfet_01v8 l=0.5 w=5
XM8 N11 N14 N12 GND sky130_fd_pr__nfet_01v8 l=0.5 w=5
XM9 Q_OUT Q_LO N10 GND sky130_fd_pr__nfet_01v8 l=0.5 w=5
XM10 Q_OUT VDD N10 GND sky130_fd_pr__nfet_01v8 l=0.5 w=5
XM11 I_OUT I_LO N4 GND sky130_fd_pr__nfet_01v8 l=0.5 w=5
XM12 I_OUT N3 N5 GND sky130_fd_pr__nfet_01v8 l=0.5 w=5
XM14 N4 N16 N11 GND sky130_fd_pr__nfet_01v8 l=0.5 w=5
XM13 N5 BIAS2 N11 GND sky130_fd_pr__nfet_01v8 l=0.5 w=5
C1 VDD Q_OUT 1p
R1 VDD I_OUT 10k
C2 VDD I_OUT 1p
C3 VDD Q_OUT 1p
R2 VDD Q_OUT 10k
R3 N12 BIAS1 10k
R4 VDD I_OUT 10k
R5 N9 BIAS1 10k
R6 VDD Q_OUT 10k
C4 VDD I_OUT 1p
C5 N14 N14 1p
C6 N15 N14 1p

.control
set filetype=ascii

op
let vdd_current = abs(i(VVDD))
let power_dc = vdd_current * 1.8
print power_dc

print all

let vout_dc = v(N11)
print vout_dc
let vout_dc = v(N2)
print vout_dc
quit
.endc

.end
