* Testcase 000007 — Full Analysis (sky130 tt corner)
* SKY130 model header — replaces the ideal level-1 .model cards
* Ships with the demo; the paths point at the local sky130 PDK checkout.
* NOTE: libs.tech/ngspice/all.spice sets ".option scale=1.0u", so every
* instance L/W below is written in microns WITHOUT a "u" suffix.
.param mc_mm_switch=0
.param mc_pr_switch=0
.include /home/idies/workspace/Temporary/xyu1/scratch/skywater-pdk-libs-sky130_fd_pr/models/corners/tt.spice
.include /home/idies/workspace/Temporary/xyu1/scratch/skywater-pdk-libs-sky130_fd_pr/models/r+c/res_typical__cap_typical.spice
.include /home/idies/workspace/Temporary/xyu1/scratch/skywater-pdk-libs-sky130_fd_pr/models/r+c/res_typical__cap_typical__lin.spice
.include /home/idies/workspace/Temporary/xyu1/scratch/skywater-pdk-libs-sky130_fd_pr/models/corners/tt/specialized_cells.spice
.model DIDEAL D   is=1e-14 n=1
.options reltol=1e-3 itl1=500 itl2=100

* Sources
VVDD VDD 0 1.8

* Circuit
I1 N3 GND 1u
I2 VDD N0 1u
XM1 N6 N5 VDD VDD sky130_fd_pr__pfet_01v8 l=0.5 w=5
XM2 N3 N8 N6 VDD sky130_fd_pr__pfet_01v8 l=0.5 w=5
R1 N0 N9 10k
R2 N2 N4 10k
XM3 N5 N5 VDD VDD sky130_fd_pr__pfet_01v8 l=0.5 w=5
XQ1 N1 N1 GND 0 sky130_fd_pr__npn_05v5_W1p00L1p00
XQ2 N8 N4 GND 0 sky130_fd_pr__npn_05v5_W1p00L1p00
XQ3 VDD N5 N8 0 sky130_fd_pr__npn_05v5_W1p00L1p00
XQ4 N7 N7 GND 0 sky130_fd_pr__npn_05v5_W1p00L1p00
XQ5 VDD N3 N1 0 sky130_fd_pr__npn_05v5_W1p00L1p00
R3 N1 N1 10k
XQ6 N0 N0 GND 0 sky130_fd_pr__npn_05v5_W1p00L1p00
R4 N1 N7 10k

.control
set filetype=ascii

op
let vdd_current = abs(i(VVDD))
let power_dc = vdd_current * 1.8
print power_dc

print all

let vout_dc = v(N5)
print vout_dc
let vout_dc = v(N5)
print vout_dc
quit
.endc

.end
