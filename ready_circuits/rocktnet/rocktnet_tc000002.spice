* Testcase 000002 — Full Analysis (sky130 tt corner)
* SKY130 model header — replaces the ideal level-1 .model cards
* Ships with the demo; the paths point at the local sky130 PDK checkout.
* NOTE: libs.tech/ngspice/all.spice sets ".option scale=1.0u", so every
* instance L/W below is written in microns WITHOUT a "u" suffix.
.param mc_mm_switch=0
.param mc_pr_switch=0
.include /home/idies/workspace/Temporary/xyu1/scratch/skywater-pdk-libs-sky130_fd_pr/models/corners/tt.spice
.include /home/idies/workspace/Temporary/xyu1/scratch/skywater-pdk-libs-sky130_fd_pr/models/r+c/res_typical__cap_typical.spice
.include /home/idies/workspace/Temporary/xyu1/scratch/skywater-pdk-libs-sky130_fd_pr/models/r+c/res_typical__cap_typical__lin.spice
.include /home/idies/workspace/Temporary/xyu1/scratch/skywater-pdk-libs-sky130_fd_pr/models/corners/tt/specialized_cells.spice
.model DIDEAL D   is=1e-14 n=1
.options reltol=1e-3 itl1=500 itl2=100

* Sources
VVDD VDD 0 1.8
VIN0 IN0 0 DC 0.9 AC 1 SIN(0.9 0.1 1MEG 0 0)
VINB0 INB0 0 DC 0.9 AC 1 SIN(0.9 0.1 1MEG 0 0)

* Circuit
XM10 N1 CLK VDD VDD sky130_fd_pr__pfet_01v8 l=0.5 w=5
XM8 N2 CLK VDD VDD sky130_fd_pr__pfet_01v8 l=0.5 w=5
XM18 N1 IN0 N5 GND sky130_fd_pr__nfet_01v8 l=0.5 w=5
XM7 N5 OFFCTRL N3 GND sky130_fd_pr__nfet_01v8 l=0.5 w=5
XM16 N1 IN0 N3 GND sky130_fd_pr__nfet_01v8 l=0.5 w=5
XM3 N3 CLK GND GND sky130_fd_pr__nfet_01v8 l=0.5 w=5
XM2 N2 INB0 N6 GND sky130_fd_pr__nfet_01v8 l=0.5 w=5
XM15 N6 OFFCTRL N4 GND sky130_fd_pr__nfet_01v8 l=0.5 w=5
XM17 N2 INB0 N4 GND sky130_fd_pr__nfet_01v8 l=0.5 w=5
XM12 N4 CLK GND GND sky130_fd_pr__nfet_01v8 l=0.5 w=5
XM4 OUT N1 VDD VDD sky130_fd_pr__pfet_01v8 l=0.5 w=5
XM5 OUT OUTB VDD VDD sky130_fd_pr__pfet_01v8 l=0.5 w=5
XM1 OUTB N2 VDD VDD sky130_fd_pr__pfet_01v8 l=0.5 w=5
XM14 OUTB OUT VDD VDD sky130_fd_pr__pfet_01v8 l=0.5 w=5
XM9 OUT N1 GND GND sky130_fd_pr__nfet_01v8 l=0.5 w=5
XM13 OUT OUTB GND GND sky130_fd_pr__nfet_01v8 l=0.5 w=5
XM6 OUTB N2 GND GND sky130_fd_pr__nfet_01v8 l=0.5 w=5
XM11 OUTB OUT GND GND sky130_fd_pr__nfet_01v8 l=0.5 w=5

.control
set filetype=ascii

op
let vdd_current = abs(i(VVDD))
let power_dc = vdd_current * 1.8
print power_dc

ac dec 100 1 10g
let vout_mag = vm(OUT)
let gain_db = db(vout_mag)
let dc_gain_db = gain_db[0]
print dc_gain_db

if dc_gain_db > 0
    meas ac ugbw WHEN gain_db=0 CROSS=1
end

quit
.endc

.end
