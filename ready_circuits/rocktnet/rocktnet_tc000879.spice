* Testcase 000879 — Full Analysis (sky130 tt corner)
* SKY130 model header — replaces the ideal level-1 .model cards
* Ships with the demo; the paths point at the local sky130 PDK checkout.
* NOTE: libs.tech/ngspice/all.spice sets ".option scale=1.0u", so every
* instance L/W below is written in microns WITHOUT a "u" suffix.
.param mc_mm_switch=0
.param mc_pr_switch=0
.include /home/idies/workspace/Temporary/xyu1/scratch/skywater-pdk-libs-sky130_fd_pr/models/corners/tt.spice
.include /home/idies/workspace/Temporary/xyu1/scratch/skywater-pdk-libs-sky130_fd_pr/models/r+c/res_typical__cap_typical.spice
.include /home/idies/workspace/Temporary/xyu1/scratch/skywater-pdk-libs-sky130_fd_pr/models/r+c/res_typical__cap_typical__lin.spice
.include /home/idies/workspace/Temporary/xyu1/scratch/skywater-pdk-libs-sky130_fd_pr/models/corners/tt/specialized_cells.spice
.model DIDEAL D   is=1e-14 n=1
.options reltol=1e-3 itl1=500 itl2=100

* Sources
VVDD VDD 0 1.8
VVIN VIN 0 DC 0.9 AC 1 SIN(0.9 0.1 1MEG 0 0)

* Circuit
IO VDD N2 1u
XM1 N1 N1 VDD VDD sky130_fd_pr__pfet_01v8 l=0.5 w=5
XM2 N3 N12 VDD VDD sky130_fd_pr__pfet_01v8 l=0.5 w=5
XM3 N5 N5 VDD VDD sky130_fd_pr__pfet_01v8 l=0.5 w=5
XM4 OUT N5 VDD VDD sky130_fd_pr__pfet_01v8 l=0.5 w=5
XM5 VDD N2 N7 GND sky130_fd_pr__nfet_01v8 l=0.5 w=5
XM6 VDD N3 N8 GND sky130_fd_pr__nfet_01v8 l=0.5 w=5
XQ1 N1 VIP GND 0 sky130_fd_pr__npn_05v5_W1p00L1p00
XQ2 N1 VIN GND 0 sky130_fd_pr__npn_05v5_W1p00L1p00
XQ3 N3 N8 N6 0 sky130_fd_pr__npn_05v5_W1p00L1p00
XQ4 N5 N8 N0 0 sky130_fd_pr__npn_05v5_W1p00L1p00
XQX1 N2 N11 GND 0 sky130_fd_pr__npn_05v5_W1p00L1p00
XQX2 N3 N10 GND 0 sky130_fd_pr__npn_05v5_W1p00L1p00
R1 N1 N12 10k
R2 N0 GND 10k
R3 N7 VIP 10k
R4 N7 N10 10k
R5 N6 GND 10k
R6 N7 N11 10k
R7 N7 VIN 10k
C1 N12 GND 1p
C2 VIP GND 1p
C3 VIN GND 1p

.control
set filetype=ascii

op
let vdd_current = abs(i(VVDD))
let power_dc = vdd_current * 1.8
print power_dc

ac dec 100 1 10g
let vout_mag = vm(OUT)
let gain_db = db(vout_mag)
let dc_gain_db = gain_db[0]
print dc_gain_db

if dc_gain_db > 0
    meas ac ugbw WHEN gain_db=0 CROSS=1
end

quit
.endc

.end
