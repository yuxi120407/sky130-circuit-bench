* Testcase 000959 — Full Analysis (sky130 tt corner)
* SKY130 model header — replaces the ideal level-1 .model cards
* Ships with the demo; the paths point at the local sky130 PDK checkout.
* NOTE: libs.tech/ngspice/all.spice sets ".option scale=1.0u", so every
* instance L/W below is written in microns WITHOUT a "u" suffix.
.param mc_mm_switch=0
.param mc_pr_switch=0
.include /home/idies/workspace/Temporary/xyu1/scratch/skywater-pdk-libs-sky130_fd_pr/models/corners/tt.spice
.include /home/idies/workspace/Temporary/xyu1/scratch/skywater-pdk-libs-sky130_fd_pr/models/r+c/res_typical__cap_typical.spice
.include /home/idies/workspace/Temporary/xyu1/scratch/skywater-pdk-libs-sky130_fd_pr/models/r+c/res_typical__cap_typical__lin.spice
.include /home/idies/workspace/Temporary/xyu1/scratch/skywater-pdk-libs-sky130_fd_pr/models/corners/tt/specialized_cells.spice
.model DIDEAL D   is=1e-14 n=1
.options reltol=1e-3 itl1=500 itl2=100

* Sources
VINJ INJ 0 DC 0.9 AC 1 SIN(0.9 0.1 1MEG 0 0)
VINJ_B INJ_B 0 DC 0.9 AC 1 SIN(0.9 0.1 1MEG 0 0)
VVBIAS VBIAS 0 0.75

* Circuit
XQ1 N_RL2 INJ N_Q1E 0 sky130_fd_pr__npn_05v5_W1p00L1p00
XQ2 N_RL1 INJ_B N_Q1E 0 sky130_fd_pr__npn_05v5_W1p00L1p00
XQ3 N_RL1 N_Q6E N_Q3E 0 sky130_fd_pr__npn_05v5_W1p00L1p00
XQ4 N_RL2 N_Q5E N_Q3E 0 sky130_fd_pr__npn_05v5_W1p00L1p00
XQ5 GND N_RL2 N_Q5E 0 sky130_fd_pr__npn_05v5_W1p00L1p00
XQ6 GND N_RL1 N_Q6E 0 sky130_fd_pr__npn_05v5_W1p00L1p00
XQ7 N_RL3 INJ N_Q9E 0 sky130_fd_pr__npn_05v5_W1p00L1p00
XQ8 N_RL3 X2_B N_Q10E 0 sky130_fd_pr__npn_05v5_W1p00L1p00
XQ9 N_RL4 X2 N_Q9E 0 sky130_fd_pr__npn_05v5_W1p00L1p00
XQ10 N_RL4 INJ_B N_Q10E 0 sky130_fd_pr__npn_05v5_W1p00L1p00
XQ11 GND N_RL3 X2_B 0 sky130_fd_pr__npn_05v5_W1p00L1p00
XQ12 GND N_RL4 X2 0 sky130_fd_pr__npn_05v5_W1p00L1p00
RL1 GND N_RL1 10k
RL2 GND N_RL2 10k
RL3 GND N_RL3 10k
RL4 GND N_RL4 10k
RS1 N_Q6E N_M5D 10k
RS2 N_Q5E N_M7D 10k
RS3 X2_B N_M13D 10k
RS4 X2 N_M15D 10k
RB N_RB VEE 10k
RB1 N_RB1 VEE 10k
RB2 N_RB2 VEE 10k
RB3 N_RB3 VEE 10k
RB4 N_RB4 VEE 10k
RB5 N_RB5 VEE 10k
RB6 N_RB6 VEE 10k
RB7 N_RB7 VEE 10k
RB8 N_RB8 VEE 10k
CC1 N_RL3 X2_B 1p
CC2 N_RL4 X2 1p
I0 VBIAS VG2 1u
XMA VG2 VG2 VG1 VEE sky130_fd_pr__nfet_01v8 l=0.5 w=5
XMB VG1 VG1 N_RB VEE sky130_fd_pr__nfet_01v8 l=0.5 w=5
XM1 N_Q1E VG2 N_M1S VEE sky130_fd_pr__nfet_01v8 l=0.5 w=5
XM2 N_M1S VG1 N_RB1 VEE sky130_fd_pr__nfet_01v8 l=0.5 w=5
XM3 N_Q3E VG2 N_M3S VEE sky130_fd_pr__nfet_01v8 l=0.5 w=5
XM4 N_M3S VG1 N_RB2 VEE sky130_fd_pr__nfet_01v8 l=0.5 w=5
XM5 N_M5D VG2 N_M5S VEE sky130_fd_pr__nfet_01v8 l=0.5 w=5
XM6 N_M5S VG1 N_RB3 VEE sky130_fd_pr__nfet_01v8 l=0.5 w=5
XM7 N_M7D VG2 N_M7S VEE sky130_fd_pr__nfet_01v8 l=0.5 w=5
XM8 N_M7S VG1 N_RB4 VEE sky130_fd_pr__nfet_01v8 l=0.5 w=5
XM9 N_Q10E VG2 N_M9S VEE sky130_fd_pr__nfet_01v8 l=0.5 w=5
XM10 N_M9S VG1 N_RB5 VEE sky130_fd_pr__nfet_01v8 l=0.5 w=5
XM11 N_Q9E VG2 N_M11S VEE sky130_fd_pr__nfet_01v8 l=0.5 w=5
XM12 N_M11S VG1 N_RB6 VEE sky130_fd_pr__nfet_01v8 l=0.5 w=5
XM13 N_M13D VG2 N_M13S VEE sky130_fd_pr__nfet_01v8 l=0.5 w=5
XM14 N_M13S VG1 N_RB7 VEE sky130_fd_pr__nfet_01v8 l=0.5 w=5
XM15 N_M15D VG2 N_M15S VEE sky130_fd_pr__nfet_01v8 l=0.5 w=5
XM16 N_M15S VG1 N_RB8 VEE sky130_fd_pr__nfet_01v8 l=0.5 w=5

.control
set filetype=ascii

op
let vdd_current = abs(i(VVDD))
let power_dc = vdd_current * 1.8
print power_dc

ac dec 100 1 10g
let vout_mag = vm(N_RL1)
let gain_db = db(vout_mag)
let dc_gain_db = gain_db[0]
print dc_gain_db

if dc_gain_db > 0
    meas ac ugbw WHEN gain_db=0 CROSS=1
end

quit
.endc

.end
