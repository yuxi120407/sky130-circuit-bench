* Testcase 000512 — Full Analysis (sky130 tt corner)
* SKY130 model header — replaces the ideal level-1 .model cards
* Ships with the demo; the paths point at the local sky130 PDK checkout.
* NOTE: libs.tech/ngspice/all.spice sets ".option scale=1.0u", so every
* instance L/W below is written in microns WITHOUT a "u" suffix.
.param mc_mm_switch=0
.param mc_pr_switch=0
.include /home/idies/workspace/Temporary/xyu1/scratch/skywater-pdk-libs-sky130_fd_pr/models/corners/tt.spice
.include /home/idies/workspace/Temporary/xyu1/scratch/skywater-pdk-libs-sky130_fd_pr/models/r+c/res_typical__cap_typical.spice
.include /home/idies/workspace/Temporary/xyu1/scratch/skywater-pdk-libs-sky130_fd_pr/models/r+c/res_typical__cap_typical__lin.spice
.include /home/idies/workspace/Temporary/xyu1/scratch/skywater-pdk-libs-sky130_fd_pr/models/corners/tt/specialized_cells.spice
.model DIDEAL D   is=1e-14 n=1
.options reltol=1e-3 itl1=500 itl2=100

* Sources
VVDD VDD 0 1.8

* Circuit
I_MT VDD N3 1u
I_ST1 VDD N1 1u
I_ST2 VDD N7 1u
I_ST3 VDD N6 1u
I_ST4 VDD N5 1u
XM1 LOAD N4 GND GND sky130_fd_pr__nfet_01v8 l=0.5 w=5
XM2 N1 N1 GND GND sky130_fd_pr__nfet_01v8 l=0.5 w=5
XM3 LOAD N0 GND GND sky130_fd_pr__nfet_01v8 l=0.5 w=5
XM4 N3 N3 GND GND sky130_fd_pr__nfet_01v8 l=0.5 w=5
R1 N3 N4 10k
C1 N0 RFIN 1p
C2 N4 RFIN 1p
R2 N0 N1 10k

.control
set filetype=ascii

op
let vdd_current = abs(i(VVDD))
let power_dc = vdd_current * 1.8
print power_dc

print all

let vout_dc = v(N1)
print vout_dc
let vout_dc = v(LOAD)
print vout_dc
quit
.endc

.end
