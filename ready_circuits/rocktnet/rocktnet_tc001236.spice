* Testcase 001236 — Full Analysis (sky130 tt corner)
* SKY130 model header — replaces the ideal level-1 .model cards
* Ships with the demo; the paths point at the local sky130 PDK checkout.
* NOTE: libs.tech/ngspice/all.spice sets ".option scale=1.0u", so every
* instance L/W below is written in microns WITHOUT a "u" suffix.
.param mc_mm_switch=0
.param mc_pr_switch=0
.include /home/idies/workspace/Temporary/xyu1/scratch/skywater-pdk-libs-sky130_fd_pr/models/corners/tt.spice
.include /home/idies/workspace/Temporary/xyu1/scratch/skywater-pdk-libs-sky130_fd_pr/models/r+c/res_typical__cap_typical.spice
.include /home/idies/workspace/Temporary/xyu1/scratch/skywater-pdk-libs-sky130_fd_pr/models/r+c/res_typical__cap_typical__lin.spice
.include /home/idies/workspace/Temporary/xyu1/scratch/skywater-pdk-libs-sky130_fd_pr/models/corners/tt/specialized_cells.spice
.model DIDEAL D   is=1e-14 n=1
.options reltol=1e-3 itl1=500 itl2=100

* Sources
VVDD VDD 0 1.8
VINn INn 0 DC 0.9 AC 1 SIN(0.9 0.1 1MEG 0 0)
VINp INp 0 DC 0.9 AC 1 SIN(0.9 0.1 1MEG 0 0)

* Circuit
XQ1 GND N0 OUTp 0 sky130_fd_pr__npn_05v5_W1p00L1p00
XQ2 GND N7 N9 0 sky130_fd_pr__npn_05v5_W1p00L1p00
XM1 N3 N2 GND VDD sky130_fd_pr__pfet_01v8 l=0.5 w=5
XM2 N0 N2 GND VDD sky130_fd_pr__pfet_01v8 l=0.5 w=5
I1 N6 GND 1u
XQ3 N0 INn N4 0 sky130_fd_pr__npn_05v5_W1p00L1p00
XQ4 N3 INp N4 0 sky130_fd_pr__npn_05v5_W1p00L1p00
I2 OUTp GND 1u
R1 N6 N8 10k
XQ5 GND N3 OUTn 0 sky130_fd_pr__npn_05v5_W1p00L1p00
XQ6 N2 GND N8 0 sky130_fd_pr__npn_05v5_W1p00L1p00
R2 N6 N9 10k
XM3 N2 N2 GND VDD sky130_fd_pr__pfet_01v8 l=0.5 w=5
R3 OUTn N7 10k
I3 OUTn GND 1u
R4 OUTp N7 10k
I4 N4 GND 1u

.control
set filetype=ascii

op
let vdd_current = abs(i(VVDD))
let power_dc = vdd_current * 1.8
print power_dc

ac dec 100 1 10g
let vout_mag = vm(OUTp)
let gain_db = db(vout_mag)
let dc_gain_db = gain_db[0]
print dc_gain_db

if dc_gain_db > 0
    meas ac ugbw WHEN gain_db=0 CROSS=1
end

quit
.endc

.end
