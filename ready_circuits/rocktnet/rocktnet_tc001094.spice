* Testcase 001094 — Full Analysis (sky130 tt corner)
* SKY130 model header — replaces the ideal level-1 .model cards
* Ships with the demo; the paths point at the local sky130 PDK checkout.
* NOTE: libs.tech/ngspice/all.spice sets ".option scale=1.0u", so every
* instance L/W below is written in microns WITHOUT a "u" suffix.
.param mc_mm_switch=0
.param mc_pr_switch=0
.include /home/idies/workspace/Temporary/xyu1/scratch/skywater-pdk-libs-sky130_fd_pr/models/corners/tt.spice
.include /home/idies/workspace/Temporary/xyu1/scratch/skywater-pdk-libs-sky130_fd_pr/models/r+c/res_typical__cap_typical.spice
.include /home/idies/workspace/Temporary/xyu1/scratch/skywater-pdk-libs-sky130_fd_pr/models/r+c/res_typical__cap_typical__lin.spice
.include /home/idies/workspace/Temporary/xyu1/scratch/skywater-pdk-libs-sky130_fd_pr/models/corners/tt/specialized_cells.spice
.model DIDEAL D   is=1e-14 n=1
.options reltol=1e-3 itl1=500 itl2=100

* Sources
VVDD VDD 0 1.8
VVSS VSS 0 0
VVBIAS1 VBIAS1 0 0.9900000000000001
VVBIAS VBIAS 0 0.54
VVBIAS2 VBIAS2 0 0.54
VINp INp 0 DC 0.9 AC 1 SIN(0.9 0.1 1MEG 0 0)
VINn INn 0 DC 0.9 AC 1 SIN(0.9 0.1 1MEG 0 0)

* Circuit
XM1 N1 VBIAS1 VDD VDD sky130_fd_pr__pfet_01v8 l=0.5 w=5
XM2 N4 VBIAS1 VDD VDD sky130_fd_pr__pfet_01v8 l=0.5 w=5
XM3 N1 VBIAS VSS VSS sky130_fd_pr__nfet_01v8 l=0.5 w=5
XM4 N5 VBIAS VSS VSS sky130_fd_pr__nfet_01v8 l=0.5 w=5
R1 N1 VBIAS 10k
XM5 VBIAS N2 VSS VSS sky130_fd_pr__nfet_01v8 l=0.5 w=5
XM6 N2 VBIAS2 VSS VSS sky130_fd_pr__nfet_01v8 l=0.5 w=5
XM7 N2 N2 N1 VDD sky130_fd_pr__pfet_01v8 l=0.5 w=5
XM8 N4 INp N5 VSS sky130_fd_pr__nfet_01v8 l=0.5 w=5
XM9 N4 INn N5 VSS sky130_fd_pr__nfet_01v8 l=0.5 w=5

.control
set filetype=ascii

op
let vdd_current = abs(i(VVDD))
let power_dc = vdd_current * 1.8
print power_dc

print all

let vout_dc = v(N2)
print vout_dc
let vout_dc = v(VBIAS1)
print vout_dc
quit
.endc

.end
