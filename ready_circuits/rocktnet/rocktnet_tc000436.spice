* Testcase 000436 — Full Analysis (sky130 tt corner)
* SKY130 model header — replaces the ideal level-1 .model cards
* Ships with the demo; the paths point at the local sky130 PDK checkout.
* NOTE: libs.tech/ngspice/all.spice sets ".option scale=1.0u", so every
* instance L/W below is written in microns WITHOUT a "u" suffix.
.param mc_mm_switch=0
.param mc_pr_switch=0
.include /home/idies/workspace/Temporary/xyu1/scratch/skywater-pdk-libs-sky130_fd_pr/models/corners/tt.spice
.include /home/idies/workspace/Temporary/xyu1/scratch/skywater-pdk-libs-sky130_fd_pr/models/r+c/res_typical__cap_typical.spice
.include /home/idies/workspace/Temporary/xyu1/scratch/skywater-pdk-libs-sky130_fd_pr/models/r+c/res_typical__cap_typical__lin.spice
.include /home/idies/workspace/Temporary/xyu1/scratch/skywater-pdk-libs-sky130_fd_pr/models/corners/tt/specialized_cells.spice
.model DIDEAL D   is=1e-14 n=1
.options reltol=1e-2 abstol=1e-10 vntol=1e-4 itl1=1000 itl2=200 itl4=100
.options gmin=1e-10 method=gear

* Sources
VVSS VSS 0 0

* Circuit
R1 OUTN GND 10k
R2 VSS OUTP 10k
R3 VSS OUTN 10k
XM1 OUTN DINN N1 GND sky130_fd_pr__nfet_01v8 l=0.5 w=5
R4 OUTP GND 10k
XM2 OUTN DINP N1 GND sky130_fd_pr__nfet_01v8 l=0.5 w=5
XM3 N1 VOA VSS GND sky130_fd_pr__nfet_01v8 l=0.5 w=5
XM4 OUTN OUTN OUTP GND sky130_fd_pr__nfet_01v8 l=0.5 w=5

.control
set filetype=ascii

op
let power_dc = abs(i(VVSS)) * 1.8
print power_dc
let dc_voltage = v(OUTN)
print dc_voltage
print all

quit
.endc

.end
