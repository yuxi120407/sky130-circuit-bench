* Testcase 000537 — Full Analysis (sky130 tt corner)
* SKY130 model header — replaces the ideal level-1 .model cards
* Ships with the demo; the paths point at the local sky130 PDK checkout.
* NOTE: libs.tech/ngspice/all.spice sets ".option scale=1.0u", so every
* instance L/W below is written in microns WITHOUT a "u" suffix.
.param mc_mm_switch=0
.param mc_pr_switch=0
.include /home/idies/workspace/Temporary/xyu1/scratch/skywater-pdk-libs-sky130_fd_pr/models/corners/tt.spice
.include /home/idies/workspace/Temporary/xyu1/scratch/skywater-pdk-libs-sky130_fd_pr/models/r+c/res_typical__cap_typical.spice
.include /home/idies/workspace/Temporary/xyu1/scratch/skywater-pdk-libs-sky130_fd_pr/models/r+c/res_typical__cap_typical__lin.spice
.include /home/idies/workspace/Temporary/xyu1/scratch/skywater-pdk-libs-sky130_fd_pr/models/corners/tt/specialized_cells.spice
.model DIDEAL D   is=1e-14 n=1
.options reltol=1e-3 itl1=500 itl2=100

* Sources
VVDD VDD 0 1.8
VLABEL_NET_0 LABEL_NET_0 0 0.9
VLABEL_NET_1 LABEL_NET_1 0 0.9
VLABEL_NET_2 LABEL_NET_2 0 0.9
VLABEL_NET_3 LABEL_NET_3 0 DC 0.9 AC 1
VLABEL_NET_4 LABEL_NET_4 0 0.9
VLABEL_NET_5 LABEL_NET_5 0 0.9
VLABEL_NET_6 LABEL_NET_6 0 0.9
VLABEL_NET_7 LABEL_NET_7 0 0.9
VLABEL_NET_8 LABEL_NET_8 0 0.9
VLABEL_NET_9 LABEL_NET_9 0 0.9

* Circuit
I1 N1 GND 1u
I2 LABEL_NET_0 N2 1u
I3 N0 GND 1u
I4 LABEL_NET_1 N4 1u
XM1 N3 LABEL_NET_2 N1 GND sky130_fd_pr__nfet_01v8 l=0.5 w=5
XM2 N3 LABEL_NET_3 N2 VDD sky130_fd_pr__pfet_01v8 l=0.5 w=5
XM3 N3 LABEL_NET_4 N2 VDD sky130_fd_pr__pfet_01v8 l=0.5 w=5
XM4 N0 LABEL_NET_5 N0 GND sky130_fd_pr__nfet_01v8 l=0.5 w=5
XM5 N3 LABEL_NET_6 N4 VDD sky130_fd_pr__pfet_01v8 l=0.5 w=5
XM6 N3 LABEL_NET_7 N4 VDD sky130_fd_pr__pfet_01v8 l=0.5 w=5
R1 N3 N5 10k
R2 N3 N5 10k
XM7 N3 LABEL_NET_8 N1 GND sky130_fd_pr__nfet_01v8 l=0.5 w=5
XM8 N3 LABEL_NET_9 N0 GND sky130_fd_pr__nfet_01v8 l=0.5 w=5

.control
set filetype=ascii

op
let power_dc = abs(i(VVDD)) * 1.8
print power_dc

ac dec 100 1 10g
let gain_N2 = db(vm(N2))
let gain_N4 = db(vm(N4))
let gain_N0 = db(vm(N0))
let gain_N1 = db(vm(N1))
let gain_N3 = db(vm(N3))
meas ac max_gain_N2 MAX gain_N2
meas ac max_gain_N4 MAX gain_N4
meas ac max_gain_N0 MAX gain_N0
meas ac max_gain_N1 MAX gain_N1
meas ac max_gain_N3 MAX gain_N3

* Use first probe node for standard metrics
let gain_db = db(vm(N2))
meas ac dc_gain_db FIND gain_db AT=1
meas ac ugbw WHEN gain_db=0 CROSS=1
let vout_dc = v(N2)

print dc_gain_db ugbw vout_dc gain_N2 gain_N4 gain_N0 gain_N1 gain_N3

quit
.endc

.end
