* Testcase 000813 — Full Analysis (sky130 tt corner)
* SKY130 model header — replaces the ideal level-1 .model cards
* Ships with the demo; the paths point at the local sky130 PDK checkout.
* NOTE: libs.tech/ngspice/all.spice sets ".option scale=1.0u", so every
* instance L/W below is written in microns WITHOUT a "u" suffix.
.param mc_mm_switch=0
.param mc_pr_switch=0
.include /home/idies/workspace/Temporary/xyu1/scratch/skywater-pdk-libs-sky130_fd_pr/models/corners/tt.spice
.include /home/idies/workspace/Temporary/xyu1/scratch/skywater-pdk-libs-sky130_fd_pr/models/r+c/res_typical__cap_typical.spice
.include /home/idies/workspace/Temporary/xyu1/scratch/skywater-pdk-libs-sky130_fd_pr/models/r+c/res_typical__cap_typical__lin.spice
.include /home/idies/workspace/Temporary/xyu1/scratch/skywater-pdk-libs-sky130_fd_pr/models/corners/tt/specialized_cells.spice
.model DIDEAL D   is=1e-14 n=1
.options reltol=1e-3 itl1=500 itl2=100

* Sources
VVDD VDD 0 1.8
VVBIAS VBIAS 0 0.54
VVINN VINN 0 DC 0.9 AC 1 SIN(0.9 0.1 1MEG 0 0)
VVINP VINP 0 DC 0.9 AC 1 SIN(0.9 0.1 1MEG 0 0)

* Circuit
XM3A VOUTP N2 VDD VDD sky130_fd_pr__pfet_01v8 l=0.5 w=5
XM4A VOUTP VBIAS GND GND sky130_fd_pr__nfet_01v8 l=0.5 w=5
XM2A N2 N2 VDD VDD sky130_fd_pr__pfet_01v8 l=0.5 w=5
XM2B N0 N0 VDD VDD sky130_fd_pr__pfet_01v8 l=0.5 w=5
XM3B VOUTN N0 VDD VDD sky130_fd_pr__pfet_01v8 l=0.5 w=5
XM5 N1 VBIAS GND GND sky130_fd_pr__nfet_01v8 l=0.5 w=5
XM1B N0 VINN N1 GND sky130_fd_pr__nfet_01v8 l=0.5 w=5
XM1A N2 VINP N1 GND sky130_fd_pr__nfet_01v8 l=0.5 w=5
XM4B VOUTN VBIAS GND GND sky130_fd_pr__nfet_01v8 l=0.5 w=5

.control
set filetype=ascii

op
let vdd_current = abs(i(VVDD))
let power_dc = vdd_current * 1.8
print power_dc

print all

quit
.endc

.end
