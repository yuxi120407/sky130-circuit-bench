* Testcase 001141 — Full Analysis (sky130 tt corner)
* SKY130 model header — replaces the ideal level-1 .model cards
* Ships with the demo; the paths point at the local sky130 PDK checkout.
* NOTE: libs.tech/ngspice/all.spice sets ".option scale=1.0u", so every
* instance L/W below is written in microns WITHOUT a "u" suffix.
.param mc_mm_switch=0
.param mc_pr_switch=0
.include /home/idies/workspace/Temporary/xyu1/scratch/skywater-pdk-libs-sky130_fd_pr/models/corners/tt.spice
.include /home/idies/workspace/Temporary/xyu1/scratch/skywater-pdk-libs-sky130_fd_pr/models/r+c/res_typical__cap_typical.spice
.include /home/idies/workspace/Temporary/xyu1/scratch/skywater-pdk-libs-sky130_fd_pr/models/r+c/res_typical__cap_typical__lin.spice
.include /home/idies/workspace/Temporary/xyu1/scratch/skywater-pdk-libs-sky130_fd_pr/models/corners/tt/specialized_cells.spice
.model DIDEAL D   is=1e-14 n=1
.options reltol=1e-3 itl1=500 itl2=100

* Sources
VVDD VDD 0 1.8

* Circuit
XM1 VO_MINUS VI_PLUS N1 GND sky130_fd_pr__nfet_01v8 l=0.5 w=5
XM2 VO_MINUS VDD VDD VDD sky130_fd_pr__pfet_01v8 l=0.5 w=5
XM3 N2 VREPLICA GND GND sky130_fd_pr__nfet_01v8 l=0.5 w=5
XM4 VO_PLUS RST VDD VDD sky130_fd_pr__pfet_01v8 l=0.5 w=5
XM5 N1 VDD N2 GND sky130_fd_pr__nfet_01v8 l=0.5 w=5
XM6 VO_PLUS VI_MINUS N1 GND sky130_fd_pr__nfet_01v8 l=0.5 w=5
XM7 VO_PLUS VC VDD VDD sky130_fd_pr__pfet_01v8 l=0.5 w=5
XM8 VO_MINUS VC VDD VDD sky130_fd_pr__pfet_01v8 l=0.5 w=5

.control
set filetype=ascii

op
let vdd_current = abs(i(VVDD))
let power_dc = vdd_current * 1.8
print power_dc

print all

let vout_dc = v(VO_MINUS)
print vout_dc
let vout_dc = v(N2)
print vout_dc
quit
.endc

.end
