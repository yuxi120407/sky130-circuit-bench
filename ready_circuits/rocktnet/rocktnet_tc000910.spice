* Testcase 000910 — Full Analysis (sky130 tt corner)
* SKY130 model header — replaces the ideal level-1 .model cards
* Ships with the demo; the paths point at the local sky130 PDK checkout.
* NOTE: libs.tech/ngspice/all.spice sets ".option scale=1.0u", so every
* instance L/W below is written in microns WITHOUT a "u" suffix.
.param mc_mm_switch=0
.param mc_pr_switch=0
.include /home/idies/workspace/Temporary/xyu1/scratch/skywater-pdk-libs-sky130_fd_pr/models/corners/tt.spice
.include /home/idies/workspace/Temporary/xyu1/scratch/skywater-pdk-libs-sky130_fd_pr/models/r+c/res_typical__cap_typical.spice
.include /home/idies/workspace/Temporary/xyu1/scratch/skywater-pdk-libs-sky130_fd_pr/models/r+c/res_typical__cap_typical__lin.spice
.include /home/idies/workspace/Temporary/xyu1/scratch/skywater-pdk-libs-sky130_fd_pr/models/corners/tt/specialized_cells.spice
.model DIDEAL D   is=1e-14 n=1
.options reltol=1e-3 itl1=500 itl2=100

* Sources
VVDD VDD 0 1.8

* Circuit
XM1 N_M1_D Vn N_M5_D GND sky130_fd_pr__nfet_01v8 l=0.5 w=5
XM2 N_M2_D Vp N_M5_D GND sky130_fd_pr__nfet_01v8 l=0.5 w=5
XM3 N_M1_D V_BP VDD VDD sky130_fd_pr__pfet_01v8 l=0.5 w=5
XM4 N_M2_D V_BP VDD VDD sky130_fd_pr__pfet_01v8 l=0.5 w=5
XM5 N_M5_D V_BN GND GND sky130_fd_pr__nfet_01v8 l=0.5 w=5
XM10 VOp PMOS_CASCODE_BIAS N_M1_D VDD sky130_fd_pr__pfet_01v8 l=0.5 w=5
XM11 VOn PMOS_CASCODE_BIAS N_M2_D VDD sky130_fd_pr__pfet_01v8 l=0.5 w=5
XM8 VOp NMOS_CASCODE_BIAS N_M6_D GND sky130_fd_pr__nfet_01v8 l=0.5 w=5
XM9 VOn NMOS_CASCODE_BIAS N_M7_D GND sky130_fd_pr__nfet_01v8 l=0.5 w=5
XM6 N_M6_D V_CMFB GND GND sky130_fd_pr__nfet_01v8 l=0.5 w=5
XM7 N_M7_D V_CMFB GND GND sky130_fd_pr__nfet_01v8 l=0.5 w=5
XMBP3 N_MBP3_D V_BP VDD VDD sky130_fd_pr__pfet_01v8 l=0.5 w=5
XMBP3C V_CMFB PMOS_CASCODE_BIAS N_MBP3_D VDD sky130_fd_pr__pfet_01v8 l=0.5 w=5
XMBN1C V_CMFB NMOS_CASCODE_BIAS N_MBN1_D GND sky130_fd_pr__nfet_01v8 l=0.5 w=5
XMBN1 N_MBN1_D V_CMFB GND GND sky130_fd_pr__nfet_01v8 l=0.5 w=5
XMBP2 N_MBP2_D V_BP VDD VDD sky130_fd_pr__pfet_01v8 l=0.5 w=5
XMBP2C NMOS_CASCODE_BIAS PMOS_CASCODE_BIAS N_MBP2_D VDD sky130_fd_pr__pfet_01v8 l=0.5 w=5
XMBN0C NMOS_CASCODE_BIAS NMOS_CASCODE_BIAS N_MBN0_D GND sky130_fd_pr__nfet_01v8 l=0.5 w=5
XMBN0 N_MBN0_D V_BN GND GND sky130_fd_pr__nfet_01v8 l=0.5 w=5
XMBP1 N_MBP1_D V_BP VDD VDD sky130_fd_pr__pfet_01v8 l=0.5 w=5
XMBP1C V_BP PMOS_CASCODE_BIAS N_MBP1_D VDD sky130_fd_pr__pfet_01v8 l=0.5 w=5
XMBP0 N_MBP0_D V_BP VDD VDD sky130_fd_pr__pfet_01v8 l=0.5 w=5
XMBP0C PMOS_CASCODE_BIAS PMOS_CASCODE_BIAS N_MBP0_D VDD sky130_fd_pr__pfet_01v8 l=0.5 w=5
IBIAS1 V_BP GND 1u
IBIAS2 PMOS_CASCODE_BIAS GND 1u
C3 N_C3_L N_C3_R 1p
C4 VOn V_CMFB 1p
C2 VOp V_CMFB 1p
C1 N_C1_L N_C1_R 1p

.control
set filetype=ascii

op
let power_dc = abs(i(VVDD)) * 1.8
let vout_dc = v(V_BP)
print power_dc vout_dc

quit
.endc

.end
