* Testcase 000543 — Full Analysis (sky130 tt corner)
* SKY130 model header — replaces the ideal level-1 .model cards
* Ships with the demo; the paths point at the local sky130 PDK checkout.
* NOTE: libs.tech/ngspice/all.spice sets ".option scale=1.0u", so every
* instance L/W below is written in microns WITHOUT a "u" suffix.
.param mc_mm_switch=0
.param mc_pr_switch=0
.include /home/idies/workspace/Temporary/xyu1/scratch/skywater-pdk-libs-sky130_fd_pr/models/corners/tt.spice
.include /home/idies/workspace/Temporary/xyu1/scratch/skywater-pdk-libs-sky130_fd_pr/models/r+c/res_typical__cap_typical.spice
.include /home/idies/workspace/Temporary/xyu1/scratch/skywater-pdk-libs-sky130_fd_pr/models/r+c/res_typical__cap_typical__lin.spice
.include /home/idies/workspace/Temporary/xyu1/scratch/skywater-pdk-libs-sky130_fd_pr/models/corners/tt/specialized_cells.spice
.model DIDEAL D   is=1e-14 n=1
.options reltol=1e-2 abstol=1e-10 vntol=1e-4 itl1=1000 itl2=200 itl4=100
.options gmin=1e-10 method=gear

* Sources

* Circuit
I1 GND N0 1u
L1 N0 N1 10n
L2 N0 N2 10n
C1 N1 GND 1p
C2 N2 GND 1p
XM1 N1 N2 GND GND sky130_fd_pr__nfet_01v8 l=0.5 w=5
XM2 N2 N1 GND GND sky130_fd_pr__nfet_01v8 l=0.5 w=5

.control
set filetype=ascii

op

let dc_voltage = v(N0)
print dc_voltage
print all

let vout_dc = v(N1)
print vout_dc
let vout_dc = v(N2)
print vout_dc
quit
.endc

.end
