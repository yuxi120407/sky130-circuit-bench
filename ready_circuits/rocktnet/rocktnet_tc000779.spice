* Testcase 000779 — Full Analysis (sky130 tt corner)
* SKY130 model header — replaces the ideal level-1 .model cards
* Ships with the demo; the paths point at the local sky130 PDK checkout.
* NOTE: libs.tech/ngspice/all.spice sets ".option scale=1.0u", so every
* instance L/W below is written in microns WITHOUT a "u" suffix.
.param mc_mm_switch=0
.param mc_pr_switch=0
.include /home/idies/workspace/Temporary/xyu1/scratch/skywater-pdk-libs-sky130_fd_pr/models/corners/tt.spice
.include /home/idies/workspace/Temporary/xyu1/scratch/skywater-pdk-libs-sky130_fd_pr/models/r+c/res_typical__cap_typical.spice
.include /home/idies/workspace/Temporary/xyu1/scratch/skywater-pdk-libs-sky130_fd_pr/models/r+c/res_typical__cap_typical__lin.spice
.include /home/idies/workspace/Temporary/xyu1/scratch/skywater-pdk-libs-sky130_fd_pr/models/corners/tt/specialized_cells.spice
.model DIDEAL D   is=1e-14 n=1
.options reltol=1e-3 itl1=500 itl2=100

* Sources
VVDD VDD 0 1.8
VVBIAS VBIAS 0 DC 0.9900000000000001 AC 0.5

* Circuit
XM1 N0 N3 N5 VDD sky130_fd_pr__pfet_01v8 l=0.5 w=5
XM2 N1 N0 GND GND sky130_fd_pr__nfet_01v8 l=0.5 w=5
XM3 N8 N12 VDD VDD sky130_fd_pr__pfet_01v8 l=0.5 w=5
XM4 N2 N1 GND GND sky130_fd_pr__nfet_01v8 l=0.5 w=5
XM5 N11 N4 VDD VDD sky130_fd_pr__pfet_01v8 l=0.5 w=5
XM6 N2 VBIAS VDD VDD sky130_fd_pr__pfet_01v8 l=0.5 w=5
R_T N3 GND 10k
XM7 N6 N6 VDD VDD sky130_fd_pr__pfet_01v8 l=0.5 w=5
XM8 N1 VEA N5 VDD sky130_fd_pr__pfet_01v8 l=0.5 w=5
XM9 N0 N0 GND GND sky130_fd_pr__nfet_01v8 l=0.5 w=5
XM_T N6 N2 N3 GND sky130_fd_pr__nfet_01v8 l=0.5 w=5
XM11 N4 N10 V_C GND sky130_fd_pr__nfet_01v8 l=0.5 w=5
XM_1 V_C V_C GND GND sky130_fd_pr__nfet_01v8 l=0.5 w=5
XM13 V_C N6 VDD VDD sky130_fd_pr__pfet_01v8 l=0.5 w=5
XM14 N11 N4 V_C GND sky130_fd_pr__nfet_01v8 l=0.5 w=5
XM15 N10 N8 VDD VDD sky130_fd_pr__pfet_01v8 l=0.5 w=5
XM16 N4 N10 VDD VDD sky130_fd_pr__pfet_01v8 l=0.5 w=5
C1 N1 N2 1p
XM17 N5 VBIAS VDD VDD sky130_fd_pr__pfet_01v8 l=0.5 w=5
XM18 N10 N8 V_C GND sky130_fd_pr__nfet_01v8 l=0.5 w=5
XM19 N8 N12 V_C GND sky130_fd_pr__nfet_01v8 l=0.5 w=5
C_T V_C GND 1p
XM20 N12 N11 VDD VDD sky130_fd_pr__pfet_01v8 l=0.5 w=5
XM21 N12 N11 V_C GND sky130_fd_pr__nfet_01v8 l=0.5 w=5

.control
set filetype=ascii

op
let vdd_current = abs(i(VVDD))
let power_dc = vdd_current * 1.8
print power_dc

ac dec 100 1 10g
let vout_mag = vm(N3)
let gain_db = db(vout_mag)
let dc_gain_db = gain_db[0]
print dc_gain_db

if dc_gain_db > 0
    meas ac ugbw WHEN gain_db=0 CROSS=1
end

quit
.endc

.end
