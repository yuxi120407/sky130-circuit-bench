* Testcase 000668 — Full Analysis (sky130 tt corner)
* SKY130 model header — replaces the ideal level-1 .model cards
* Ships with the demo; the paths point at the local sky130 PDK checkout.
* NOTE: libs.tech/ngspice/all.spice sets ".option scale=1.0u", so every
* instance L/W below is written in microns WITHOUT a "u" suffix.
.param mc_mm_switch=0
.param mc_pr_switch=0
.include /home/idies/workspace/Temporary/xyu1/scratch/skywater-pdk-libs-sky130_fd_pr/models/corners/tt.spice
.include /home/idies/workspace/Temporary/xyu1/scratch/skywater-pdk-libs-sky130_fd_pr/models/r+c/res_typical__cap_typical.spice
.include /home/idies/workspace/Temporary/xyu1/scratch/skywater-pdk-libs-sky130_fd_pr/models/r+c/res_typical__cap_typical__lin.spice
.include /home/idies/workspace/Temporary/xyu1/scratch/skywater-pdk-libs-sky130_fd_pr/models/corners/tt/specialized_cells.spice
.model DIDEAL D   is=1e-14 n=1
.options reltol=1e-3 itl1=500 itl2=100

* Sources
VVDD VDD 0 1.8

* Circuit
XM1 N9 GND N6 GND sky130_fd_pr__nfet_01v8 l=0.5 w=5
XM2 VOUT GND N11 GND sky130_fd_pr__nfet_01v8 l=0.5 w=5
I1 VDD N10 1u
XM3 N7 GND N3 GND sky130_fd_pr__nfet_01v8 l=0.5 w=5
XM4 N13 N0 VDD VDD sky130_fd_pr__pfet_01v8 l=0.5 w=5
XM5 N6 N9 GND GND sky130_fd_pr__nfet_01v8 l=0.5 w=5
XM6 N5 N9 GND GND sky130_fd_pr__nfet_01v8 l=0.5 w=5
XM7 N3 N7 GND GND sky130_fd_pr__nfet_01v8 l=0.5 w=5
XM8 N11 N7 GND GND sky130_fd_pr__nfet_01v8 l=0.5 w=5
XM9 N0 GND N5 GND sky130_fd_pr__nfet_01v8 l=0.5 w=5
XM10 N2 N0 VDD VDD sky130_fd_pr__pfet_01v8 l=0.5 w=5
XM11 N9 V_MINUS N10 VDD sky130_fd_pr__pfet_01v8 l=0.5 w=5
XM12 VOUT VCP N13 VDD sky130_fd_pr__pfet_01v8 l=0.5 w=5
XM13 N0 VCP N2 VDD sky130_fd_pr__pfet_01v8 l=0.5 w=5
XM14 N7 V_PLUS N10 VDD sky130_fd_pr__pfet_01v8 l=0.5 w=5

.control
set filetype=ascii

op
let vdd_current = abs(i(VVDD))
let power_dc = vdd_current * 1.8
let vout_dc = v(VOUT)
print power_dc vout_dc

quit
.endc

.end
