* Testcase 000338 — Full Analysis (sky130 tt corner)
* SKY130 model header — replaces the ideal level-1 .model cards
* Ships with the demo; the paths point at the local sky130 PDK checkout.
* NOTE: libs.tech/ngspice/all.spice sets ".option scale=1.0u", so every
* instance L/W below is written in microns WITHOUT a "u" suffix.
.param mc_mm_switch=0
.param mc_pr_switch=0
.include /home/idies/workspace/Temporary/xyu1/scratch/skywater-pdk-libs-sky130_fd_pr/models/corners/tt.spice
.include /home/idies/workspace/Temporary/xyu1/scratch/skywater-pdk-libs-sky130_fd_pr/models/r+c/res_typical__cap_typical.spice
.include /home/idies/workspace/Temporary/xyu1/scratch/skywater-pdk-libs-sky130_fd_pr/models/r+c/res_typical__cap_typical__lin.spice
.include /home/idies/workspace/Temporary/xyu1/scratch/skywater-pdk-libs-sky130_fd_pr/models/corners/tt/specialized_cells.spice
.model DIDEAL D   is=1e-14 n=1
.options reltol=1e-3 itl1=500 itl2=100

* Sources
VVDD VDD 0 1.8
VVB3 VB3 0 0.9900000000000001
VVB4 VB4 0 0.9900000000000001
VVB2 VB2 0 0.54
VVB1 VB1 0 0.54
VVINp VINp 0 DC 0.9 AC 1 SIN(0.9 0.1 1MEG 0 0)
VVINn VINn 0 DC 0.9 AC 1 SIN(0.9 0.1 1MEG 0 0)

* Circuit
XM1 N9 VB3 VDD VDD sky130_fd_pr__pfet_01v8 l=0.5 w=5
XM2 N0 VB3 VDD VDD sky130_fd_pr__pfet_01v8 l=0.5 w=5
XM3 N2 N15 N9 VDD sky130_fd_pr__pfet_01v8 l=0.5 w=5
XM4 N5 VB4 N0 VDD sky130_fd_pr__pfet_01v8 l=0.5 w=5
XM5 N1 N2 IOUTn GND sky130_fd_pr__nfet_01v8 l=0.5 w=5
XM6 N2 N5 IOUTp GND sky130_fd_pr__nfet_01v8 l=0.5 w=5
XM7 N4 VB3 VDD VDD sky130_fd_pr__pfet_01v8 l=0.5 w=5
XM8 N8 VB3 VDD VDD sky130_fd_pr__pfet_01v8 l=0.5 w=5
XM9 N15 N15 N4 VDD sky130_fd_pr__pfet_01v8 l=0.5 w=5
XM10 N14 VB4 N8 VDD sky130_fd_pr__pfet_01v8 l=0.5 w=5
XM11 N2 VB2 N19 GND sky130_fd_pr__nfet_01v8 l=0.5 w=5
XM12 N5 VB2 N17 GND sky130_fd_pr__nfet_01v8 l=0.5 w=5
XM13 IOUTn VB1 GND GND sky130_fd_pr__nfet_01v8 l=0.5 w=5
XM14 N19 VB1 GND GND sky130_fd_pr__nfet_01v8 l=0.5 w=5
XM15 N17 VB1 GND GND sky130_fd_pr__nfet_01v8 l=0.5 w=5
XM16 IOUTp VB1 GND GND sky130_fd_pr__nfet_01v8 l=0.5 w=5
XQ1 N9 VINp N1 0 sky130_fd_pr__npn_05v5_W1p00L1p00
XQ2 N0 VINn N2 0 sky130_fd_pr__npn_05v5_W1p00L1p00
C1 N9 N2 1p
C2 N0 N5 1p
R1 N1 N2 10k
R2 N15 N14 10k
R3 N1 N15 10k
R4 N2 N14 10k

.control
set filetype=ascii

op
let power_dc = abs(i(VVDD)) * 1.8
print power_dc

ac dec 100 1 10g
let vout_mag = vm(N1)
let gain_db = db(vout_mag)
let dc_gain_db = gain_db[0]
print dc_gain_db

if dc_gain_db > 0
    meas ac ugbw WHEN gain_db=0 CROSS=1
    print ugbw
end

quit
.endc

.end
