* Testcase 000202 — Full Analysis (sky130 tt corner)
* SKY130 model header — replaces the ideal level-1 .model cards
* Ships with the demo; the paths point at the local sky130 PDK checkout.
* NOTE: libs.tech/ngspice/all.spice sets ".option scale=1.0u", so every
* instance L/W below is written in microns WITHOUT a "u" suffix.
.param mc_mm_switch=0
.param mc_pr_switch=0
.include /home/idies/workspace/Temporary/xyu1/scratch/skywater-pdk-libs-sky130_fd_pr/models/corners/tt.spice
.include /home/idies/workspace/Temporary/xyu1/scratch/skywater-pdk-libs-sky130_fd_pr/models/r+c/res_typical__cap_typical.spice
.include /home/idies/workspace/Temporary/xyu1/scratch/skywater-pdk-libs-sky130_fd_pr/models/r+c/res_typical__cap_typical__lin.spice
.include /home/idies/workspace/Temporary/xyu1/scratch/skywater-pdk-libs-sky130_fd_pr/models/corners/tt/specialized_cells.spice
.model DIDEAL D   is=1e-14 n=1
.options reltol=1e-3 itl1=500 itl2=100

* Sources

* Circuit
C1 N2 N13 1p
R1 N31 VEE 10k
R2 N3 VCC 10k
R3 N18 VCC 10k
R4 N0 VCC 10k
R5 N26 VEE 10k
R6 N22 VEE 10k
R7 N23 VEE 10k
R8 N3 N7 10k
R9 N9 VCC 10k
R10 N31 VEE 10k
R11 N33 VEE 10k
R12 N9 N16 10k
R13 N27 VEE 10k
R14 N41 VEE 10k
R15 N41 VEE 10k
XQ1 VCC N0 OUT_MINUS 0 sky130_fd_pr__npn_05v5_W1p00L1p00
XQ2 N13 N25 N11 0 sky130_fd_pr__npn_05v5_W1p00L1p00
XQ3 N10 N7 N12 0 sky130_fd_pr__npn_05v5_W1p00L1p00
XQ4 N0 N0 N10 0 sky130_fd_pr__npn_05v5_W1p00L1p00
XQ5 N7 N2 N8 0 sky130_fd_pr__npn_05v5_W1p00L1p00
XQ6 VCC N18 N2 0 sky130_fd_pr__npn_05v5_W1p00L1p00
XQ7 N11 FREE_RUNNING_FREQUENCY_CONTROL N22 0 sky130_fd_pr__npn_05v5_W1p00L1p00
XQ8 N2 N6 N11 0 sky130_fd_pr__npn_05v5_W1p00L1p00
XQ9 N8 FREE_RUNNING_FREQUENCY_CONTROL N23 0 sky130_fd_pr__npn_05v5_W1p00L1p00
XQ10 N4 FREE_RUNNING_FREQUENCY_CONTROL N41 0 sky130_fd_pr__npn_05v5_W1p00L1p00
XQ11 OUT_MINUS OUT_MINUS N28 0 sky130_fd_pr__npn_05v5_W1p00L1p00
XQ12 N12 FREE_RUNNING_FREQUENCY_CONTROL N41 0 sky130_fd_pr__npn_05v5_W1p00L1p00
XQ13 N35 FREE_RUNNING_FREQUENCY_CONTROL N33 0 sky130_fd_pr__npn_05v5_W1p00L1p00
XQ14 N11 FREE_RUNNING_FREQUENCY_CONTROL N26 0 sky130_fd_pr__npn_05v5_W1p00L1p00
XQ15 N16 N13 N8 0 sky130_fd_pr__npn_05v5_W1p00L1p00
XQ16 VCC N18 OUT_PLUS 0 sky130_fd_pr__npn_05v5_W1p00L1p00
XQ17 N2 N2 N15 0 sky130_fd_pr__npn_05v5_W1p00L1p00
XQ18 N25 FROM_LPF N11 0 sky130_fd_pr__npn_05v5_W1p00L1p00
XQ19 N28 FREE_RUNNING_FREQUENCY_CONTROL N27 0 sky130_fd_pr__npn_05v5_W1p00L1p00
XQ20 N14 FREE_RUNNING_FREQUENCY_CONTROL N31 0 sky130_fd_pr__npn_05v5_W1p00L1p00
XQ21 N18 N18 N1 0 sky130_fd_pr__npn_05v5_W1p00L1p00
XQ22 N3 N16 N4 0 sky130_fd_pr__npn_05v5_W1p00L1p00
XQ23 N1 N16 N12 0 sky130_fd_pr__npn_05v5_W1p00L1p00
XQ24 OUT_PLUS OUT_PLUS N35 0 sky130_fd_pr__npn_05v5_W1p00L1p00
XQ25 VCC VCC N25 0 sky130_fd_pr__npn_05v5_W1p00L1p00
XQ26 VCC N0 N13 0 sky130_fd_pr__npn_05v5_W1p00L1p00
XQ27 N6 FROM_LPF N11 0 sky130_fd_pr__npn_05v5_W1p00L1p00
XQ28 VCC VCC N6 0 sky130_fd_pr__npn_05v5_W1p00L1p00
XQ29 N13 N13 N14 0 sky130_fd_pr__npn_05v5_W1p00L1p00
XQ30 N9 N7 N4 0 sky130_fd_pr__npn_05v5_W1p00L1p00
XQ31 N15 FREE_RUNNING_FREQUENCY_CONTROL N31 0 sky130_fd_pr__npn_05v5_W1p00L1p00

.control
set filetype=ascii

op
let power_dc = 0
print power_dc
let dc_voltage = v(N0)
print dc_voltage

quit
.endc

.end
