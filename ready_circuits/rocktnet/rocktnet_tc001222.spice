* Testcase 001222 — Full Analysis (sky130 tt corner)
* SKY130 model header — replaces the ideal level-1 .model cards
* Ships with the demo; the paths point at the local sky130 PDK checkout.
* NOTE: libs.tech/ngspice/all.spice sets ".option scale=1.0u", so every
* instance L/W below is written in microns WITHOUT a "u" suffix.
.param mc_mm_switch=0
.param mc_pr_switch=0
.include /home/idies/workspace/Temporary/xyu1/scratch/skywater-pdk-libs-sky130_fd_pr/models/corners/tt.spice
.include /home/idies/workspace/Temporary/xyu1/scratch/skywater-pdk-libs-sky130_fd_pr/models/r+c/res_typical__cap_typical.spice
.include /home/idies/workspace/Temporary/xyu1/scratch/skywater-pdk-libs-sky130_fd_pr/models/r+c/res_typical__cap_typical__lin.spice
.include /home/idies/workspace/Temporary/xyu1/scratch/skywater-pdk-libs-sky130_fd_pr/models/corners/tt/specialized_cells.spice
.model DIDEAL D   is=1e-14 n=1
.options reltol=1e-3 itl1=500 itl2=100

* Sources
VVDD VDD 0 1.8
VVBG VBG 0 DC 0.75 AC 0.5

* Circuit
R2 VBG VA 10k
RC N1 N12 10k
R1 N1 N2 10k
R3 GND VA 10k
RA N0 N4 10k
RB N10 N12 10k
XM1 N6 N8 GND GND sky130_fd_pr__nfet_01v8 l=0.5 w=5
XM2 N1 N15 N3 VDD sky130_fd_pr__pfet_01v8 l=0.5 w=5
XM3 VBG N5 N3 VDD sky130_fd_pr__pfet_01v8 l=0.5 w=5
XM4 N4 N13 N3 VDD sky130_fd_pr__pfet_01v8 l=0.5 w=5
XM5 N0 N14 N3 VDD sky130_fd_pr__pfet_01v8 l=0.5 w=5
C GND N8 1p
XMB N0 N4 GND GND sky130_fd_pr__nfet_01v8 l=0.5 w=5
XM7 N10 N15 N3 VDD sky130_fd_pr__pfet_01v8 l=0.5 w=5
XM8 N6 N6 N3 VDD sky130_fd_pr__pfet_01v8 l=0.5 w=5
XQ1 N10 N12 GND 0 sky130_fd_pr__npn_05v5_W1p00L1p00
XQ2 N2 N12 GND 0 sky130_fd_pr__npn_05v5_W1p00L1p00
XQ3 N4 N0 GND 0 sky130_fd_pr__npn_05v5_W1p00L1p00

.control
set filetype=ascii

op
let vdd_current = abs(i(VVDD))
let power_dc = vdd_current * 1.8
print power_dc

ac dec 100 1 10g
let vout_mag = vm(VA)
let gain_db = db(vout_mag)
let dc_gain_db = gain_db[0]
print dc_gain_db

if dc_gain_db > 0
    meas ac ugbw WHEN gain_db=0 CROSS=1
end

quit
.endc

.end
