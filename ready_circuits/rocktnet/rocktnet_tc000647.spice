* Testcase 000647 — Full Analysis (sky130 tt corner)
* SKY130 model header — replaces the ideal level-1 .model cards
* Ships with the demo; the paths point at the local sky130 PDK checkout.
* NOTE: libs.tech/ngspice/all.spice sets ".option scale=1.0u", so every
* instance L/W below is written in microns WITHOUT a "u" suffix.
.param mc_mm_switch=0
.param mc_pr_switch=0
.include /home/idies/workspace/Temporary/xyu1/scratch/skywater-pdk-libs-sky130_fd_pr/models/corners/tt.spice
.include /home/idies/workspace/Temporary/xyu1/scratch/skywater-pdk-libs-sky130_fd_pr/models/r+c/res_typical__cap_typical.spice
.include /home/idies/workspace/Temporary/xyu1/scratch/skywater-pdk-libs-sky130_fd_pr/models/r+c/res_typical__cap_typical__lin.spice
.include /home/idies/workspace/Temporary/xyu1/scratch/skywater-pdk-libs-sky130_fd_pr/models/corners/tt/specialized_cells.spice
.model DIDEAL D   is=1e-14 n=1
.options reltol=1e-3 itl1=500 itl2=100

* Sources
VVDD VDD 0 1.8
VVIN_PLUS VIN_PLUS 0 DC 0.9 AC 1 SIN(0.9 0.1 1MEG 0 0)
VVIN_MINUS VIN_MINUS 0 DC 0.9 AC 1 SIN(0.9 0.1 1MEG 0 0)
VLABEL_NET_0 LABEL_NET_0 0 0.9

* Circuit
XQ1 VO_PLUS VIN_PLUS VO_MINUS 0 sky130_fd_pr__npn_05v5_W1p00L1p00
XM1 N3 N3 N8 VDD sky130_fd_pr__pfet_01v8 l=0.5 w=5
XM2 N5 N3 N8 VDD sky130_fd_pr__pfet_01v8 l=0.5 w=5
XQ2 VO_PLUS VIN_MINUS VO_MINUS 0 sky130_fd_pr__npn_05v5_W1p00L1p00
RISO2 VIN_MINUS N5 10k
RISO1 N5 VIN_PLUS 10k
REXT N3 GND 10k
CISO N5 GND 1p
CD N7 GND 1p
LD VCC N7 10n
D3 N5 LABEL_NET_0 DIDEAL
D4 GND GND DIDEAL
D2 VO_MINUS GND DIDEAL
CC2 VIN_MINUS VIN_PLUS 1p
D1 VCC VO_PLUS DIDEAL
CC1 VIN_PLUS VIN_MINUS 1p

.control
set filetype=ascii

op
let vdd_current = abs(i(VVDD))
let power_dc = vdd_current * 1.8
print power_dc

ac dec 100 1k 100g
let vout_mag = vm(N3)
let gain_db = db(vout_mag)

meas ac max_gain_db MAX gain_db
meas ac bw_3db WHEN gain_db='max_gain_db-3' CROSS=1

print max_gain_db bw_3db

quit
.endc

.end
