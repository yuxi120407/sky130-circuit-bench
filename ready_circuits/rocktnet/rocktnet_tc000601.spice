* Testcase 000601 — Full Analysis (sky130 tt corner)
* SKY130 model header — replaces the ideal level-1 .model cards
* Ships with the demo; the paths point at the local sky130 PDK checkout.
* NOTE: libs.tech/ngspice/all.spice sets ".option scale=1.0u", so every
* instance L/W below is written in microns WITHOUT a "u" suffix.
.param mc_mm_switch=0
.param mc_pr_switch=0
.include /home/idies/workspace/Temporary/xyu1/scratch/skywater-pdk-libs-sky130_fd_pr/models/corners/tt.spice
.include /home/idies/workspace/Temporary/xyu1/scratch/skywater-pdk-libs-sky130_fd_pr/models/r+c/res_typical__cap_typical.spice
.include /home/idies/workspace/Temporary/xyu1/scratch/skywater-pdk-libs-sky130_fd_pr/models/r+c/res_typical__cap_typical__lin.spice
.include /home/idies/workspace/Temporary/xyu1/scratch/skywater-pdk-libs-sky130_fd_pr/models/corners/tt/specialized_cells.spice
.model DIDEAL D   is=1e-14 n=1
.options reltol=1e-3 itl1=500 itl2=100

* Sources
VVDD VDD 0 1.8
VLABEL_NET_0 LABEL_NET_0 0 0.9
VLABEL_NET_1 LABEL_NET_1 0 0.9
VLABEL_NET_2 LABEL_NET_2 0 DC 0.9 AC 1
VLABEL_NET_3 LABEL_NET_3 0 0.9
VLABEL_NET_4 LABEL_NET_4 0 0.9

* Circuit
XM1 N1 N0 VDD VDD sky130_fd_pr__pfet_01v8 l=0.5 w=5
XM2 N0 LABEL_NET_0 VDD VDD sky130_fd_pr__pfet_01v8 l=0.5 w=5
XM3 GND LABEL_NET_1 GND GND sky130_fd_pr__nfet_01v8 l=0.5 w=5
XM4 N0 N1 VDD VDD sky130_fd_pr__pfet_01v8 l=0.5 w=5
XM5 N1 LABEL_NET_2 VDD VDD sky130_fd_pr__pfet_01v8 l=0.5 w=5
XM6 N0 N1 N2 GND sky130_fd_pr__nfet_01v8 l=0.5 w=5
XM7 N1 N0 N3 GND sky130_fd_pr__nfet_01v8 l=0.5 w=5
XM8 N3 LABEL_NET_3 GND GND sky130_fd_pr__nfet_01v8 l=0.5 w=5
XM9 GND GND GND GND sky130_fd_pr__nfet_01v8 l=0.5 w=5
XM10 N2 VDD GND GND sky130_fd_pr__nfet_01v8 l=0.5 w=5
XM11 GND LABEL_NET_4 GND GND sky130_fd_pr__nfet_01v8 l=0.5 w=5

.control
set filetype=ascii

op
let power_dc = abs(i(VVDD)) * 1.8
print power_dc

ac dec 100 1 10g
let gain_N2 = db(vm(N2))
let gain_N0 = db(vm(N0))
let gain_N1 = db(vm(N1))
let gain_N3 = db(vm(N3))
meas ac max_gain_N2 MAX gain_N2
meas ac max_gain_N0 MAX gain_N0
meas ac max_gain_N1 MAX gain_N1
meas ac max_gain_N3 MAX gain_N3

* Use first probe node for standard metrics
let gain_db = db(vm(N2))
meas ac dc_gain_db FIND gain_db AT=1
meas ac ugbw WHEN gain_db=0 CROSS=1
let vout_dc = v(N2)

print dc_gain_db ugbw vout_dc gain_N2 gain_N0 gain_N1 gain_N3

quit
.endc

.end
