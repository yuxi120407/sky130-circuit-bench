* Testcase 000167 — Full Analysis (sky130 tt corner)
* SKY130 model header — replaces the ideal level-1 .model cards
* Ships with the demo; the paths point at the local sky130 PDK checkout.
* NOTE: libs.tech/ngspice/all.spice sets ".option scale=1.0u", so every
* instance L/W below is written in microns WITHOUT a "u" suffix.
.param mc_mm_switch=0
.param mc_pr_switch=0
.include /home/idies/workspace/Temporary/xyu1/scratch/skywater-pdk-libs-sky130_fd_pr/models/corners/tt.spice
.include /home/idies/workspace/Temporary/xyu1/scratch/skywater-pdk-libs-sky130_fd_pr/models/r+c/res_typical__cap_typical.spice
.include /home/idies/workspace/Temporary/xyu1/scratch/skywater-pdk-libs-sky130_fd_pr/models/r+c/res_typical__cap_typical__lin.spice
.include /home/idies/workspace/Temporary/xyu1/scratch/skywater-pdk-libs-sky130_fd_pr/models/corners/tt/specialized_cells.spice
.model DIDEAL D   is=1e-14 n=1
.options reltol=1e-3 itl1=500 itl2=100

* Sources
VVDD VDD 0 1.8
VVINP VINP 0 DC 0.9 AC 1 SIN(0.9 0.1 1MEG 0 0)
VVINN VINN 0 DC 0.9 AC 1 SIN(0.9 0.1 1MEG 0 0)

* Circuit
IS N1 GND 1u
XM10 N1 N1 VDD VDD sky130_fd_pr__pfet_01v8 l=0.5 w=5
XM11P VOUTN N1 VDD VDD sky130_fd_pr__pfet_01v8 l=0.5 w=5
XM9P N3 N1 VDD VDD sky130_fd_pr__pfet_01v8 l=0.5 w=5
XM5P N4 N1 VDD VDD sky130_fd_pr__pfet_01v8 l=0.5 w=5
XM7P N5 N1 VDD VDD sky130_fd_pr__pfet_01v8 l=0.5 w=5
XM7N N6 N1 VDD VDD sky130_fd_pr__pfet_01v8 l=0.5 w=5
XM5N N7 N1 VDD VDD sky130_fd_pr__pfet_01v8 l=0.5 w=5
XM9N N8 N1 VDD VDD sky130_fd_pr__pfet_01v8 l=0.5 w=5
XM11N VOUTP N1 VDD VDD sky130_fd_pr__pfet_01v8 l=0.5 w=5
XM12P VOUTN N3 GND GND sky130_fd_pr__nfet_01v8 l=0.5 w=5
XM8P N3 VDD N10 GND sky130_fd_pr__nfet_01v8 l=0.5 w=5
XM2P N10 GND N4 VDD sky130_fd_pr__pfet_01v8 l=0.5 w=5
XM1P N11 VINP N4 VDD sky130_fd_pr__pfet_01v8 l=0.5 w=5
XM3P N11 N11 GND GND sky130_fd_pr__nfet_01v8 l=0.5 w=5
XM4P N10 N11 GND GND sky130_fd_pr__nfet_01v8 l=0.5 w=5
XM6P N5 VDD N11 GND sky130_fd_pr__nfet_01v8 l=0.5 w=5
XM6N N6 VDD N12 GND sky130_fd_pr__nfet_01v8 l=0.5 w=5
XM1N N12 VINN N7 VDD sky130_fd_pr__pfet_01v8 l=0.5 w=5
XM2N N13 GND N7 VDD sky130_fd_pr__pfet_01v8 l=0.5 w=5
XM3N N12 N12 GND GND sky130_fd_pr__nfet_01v8 l=0.5 w=5
XM4N N13 N12 GND GND sky130_fd_pr__nfet_01v8 l=0.5 w=5
XM8N N8 VDD N13 GND sky130_fd_pr__nfet_01v8 l=0.5 w=5
XM12N VOUTP N8 GND GND sky130_fd_pr__nfet_01v8 l=0.5 w=5
CP VOUTN N14 1p
RP N14 N3 10k
CN VOUTP N15 1p
RN N15 N8 10k

.control
set filetype=ascii

op
let vdd_current = abs(i(VVDD))
let power_dc = vdd_current * 1.8
print power_dc

print all

quit
.endc

.end
