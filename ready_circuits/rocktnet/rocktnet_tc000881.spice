* Testcase 000881 — Full Analysis (sky130 tt corner)
* SKY130 model header — replaces the ideal level-1 .model cards
* Ships with the demo; the paths point at the local sky130 PDK checkout.
* NOTE: libs.tech/ngspice/all.spice sets ".option scale=1.0u", so every
* instance L/W below is written in microns WITHOUT a "u" suffix.
.param mc_mm_switch=0
.param mc_pr_switch=0
.include /home/idies/workspace/Temporary/xyu1/scratch/skywater-pdk-libs-sky130_fd_pr/models/corners/tt.spice
.include /home/idies/workspace/Temporary/xyu1/scratch/skywater-pdk-libs-sky130_fd_pr/models/r+c/res_typical__cap_typical.spice
.include /home/idies/workspace/Temporary/xyu1/scratch/skywater-pdk-libs-sky130_fd_pr/models/r+c/res_typical__cap_typical__lin.spice
.include /home/idies/workspace/Temporary/xyu1/scratch/skywater-pdk-libs-sky130_fd_pr/models/corners/tt/specialized_cells.spice
.model DIDEAL D   is=1e-14 n=1
.options reltol=1e-3 itl1=500 itl2=100

* Sources
VVDD VDD 0 1.8
VVSS VSS 0 0
VLABEL_NET_0 LABEL_NET_0 0 0.9
VLABEL_NET_1 LABEL_NET_1 0 0.9
VINP INP 0 DC 0.9 AC 1 SIN(0.9 0.1 1MEG 0 0)
VINM INM 0 DC 0.9 AC 1 SIN(0.9 0.1 1MEG 0 0)

* Circuit
XMB3 N16 N23 VSS GND sky130_fd_pr__nfet_01v8 l=0.5 w=5
XM2 OUTP N14 N1 GND sky130_fd_pr__nfet_01v8 l=0.5 w=5
IBIAS VDD N24 1u
XM3 N19 LABEL_NET_0 N2 GND sky130_fd_pr__nfet_01v8 l=0.5 w=5
XMB4 N6 N25 VSS GND sky130_fd_pr__nfet_01v8 l=0.5 w=5
XMB5 N8 N22 VSS GND sky130_fd_pr__nfet_01v8 l=0.5 w=5
XMC1 N7 N9 N6 GND sky130_fd_pr__nfet_01v8 l=0.5 w=5
XMB2 N4 N24 VSS GND sky130_fd_pr__nfet_01v8 l=0.5 w=5
XMB1 N15 N24 VSS GND sky130_fd_pr__nfet_01v8 l=0.5 w=5
XM9 OUTP OUTP N5 GND sky130_fd_pr__nfet_01v8 l=0.5 w=5
XMC4 N5 N0 N8 GND sky130_fd_pr__nfet_01v8 l=0.5 w=5
XM11 N19 LABEL_NET_1 N2 GND sky130_fd_pr__nfet_01v8 l=0.5 w=5
XMC2 N2 N11 N6 GND sky130_fd_pr__nfet_01v8 l=0.5 w=5
RB2 N17 N20 10k
XM13 OUTP OUTP N5 GND sky130_fd_pr__nfet_01v8 l=0.5 w=5
R2 VDD OUTP 10k
R3 VDD N19 10k
XM14 OUTP N19 N1 GND sky130_fd_pr__nfet_01v8 l=0.5 w=5
XM15 N19 INP N7 GND sky130_fd_pr__nfet_01v8 l=0.5 w=5
XMB8 N3 N21 N16 GND sky130_fd_pr__nfet_01v8 l=0.5 w=5
XMB7 N17 N17 N4 GND sky130_fd_pr__nfet_01v8 l=0.5 w=5
XM18 N9 CLKP N3 GND sky130_fd_pr__nfet_01v8 l=0.5 w=5
RC1 VDD N26 10k
XMC3 N1 N18 N8 GND sky130_fd_pr__nfet_01v8 l=0.5 w=5
R5 VDD OUTP 10k
XM20 N19 INM N7 GND sky130_fd_pr__nfet_01v8 l=0.5 w=5
XMC6 N24 N17 N15 GND sky130_fd_pr__nfet_01v8 l=0.5 w=5
RC2A N9 N26 10k
R7 VDD N19 10k
RB1 VDD N20 10k
XM22 N11 N9 N3 GND sky130_fd_pr__nfet_01v8 l=0.5 w=5
RC2B N11 N26 10k

.control
set filetype=ascii

op
let vdd_current = abs(i(VVDD))
let power_dc = vdd_current * 1.8
print power_dc

ac dec 100 1 10g
let vout_mag = vm(OUTP)
let gain_db = db(vout_mag)
let dc_gain_db = gain_db[0]
print dc_gain_db

if dc_gain_db > 0
    meas ac ugbw WHEN gain_db=0 CROSS=1
end

quit
.endc

.end
