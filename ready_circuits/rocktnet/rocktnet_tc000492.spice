* Testcase 000492 — Full Analysis (sky130 tt corner)
* SKY130 model header — replaces the ideal level-1 .model cards
* Ships with the demo; the paths point at the local sky130 PDK checkout.
* NOTE: libs.tech/ngspice/all.spice sets ".option scale=1.0u", so every
* instance L/W below is written in microns WITHOUT a "u" suffix.
.param mc_mm_switch=0
.param mc_pr_switch=0
.include /home/idies/workspace/Temporary/xyu1/scratch/skywater-pdk-libs-sky130_fd_pr/models/corners/tt.spice
.include /home/idies/workspace/Temporary/xyu1/scratch/skywater-pdk-libs-sky130_fd_pr/models/r+c/res_typical__cap_typical.spice
.include /home/idies/workspace/Temporary/xyu1/scratch/skywater-pdk-libs-sky130_fd_pr/models/r+c/res_typical__cap_typical__lin.spice
.include /home/idies/workspace/Temporary/xyu1/scratch/skywater-pdk-libs-sky130_fd_pr/models/corners/tt/specialized_cells.spice
.model DIDEAL D   is=1e-14 n=1
.options reltol=1e-3 itl1=500 itl2=100

* Sources
VVDD VDD 0 1.8
VLABEL_NET_0 LABEL_NET_0 0 DC 0.9 AC 0.5
VLABEL_NET_1 LABEL_NET_1 0 0.9
VLABEL_NET_2 LABEL_NET_2 0 0.9
VLABEL_NET_3 LABEL_NET_3 0 0.9

* Circuit
XM1 N2 N2 N3 GND sky130_fd_pr__nfet_01v8 l=0.5 w=5
XQ1 N0 LABEL_NET_0 N1 0 sky130_fd_pr__npn_05v5_W1p00L1p00
XQ2 N5 LABEL_NET_1 N1 0 sky130_fd_pr__npn_05v5_W1p00L1p00
XM2 N8 N12 N6 VDD sky130_fd_pr__pfet_01v8 l=0.5 w=5
XM3 N2 LABEL_NET_2 N0 VDD sky130_fd_pr__pfet_01v8 l=0.5 w=5
XM4 N11 N11 N6 VDD sky130_fd_pr__pfet_01v8 l=0.5 w=5
XM5 N10 N10 N3 GND sky130_fd_pr__nfet_01v8 l=0.5 w=5
I1 N6 N4 1u
XM6 N4 N4 N10 GND sky130_fd_pr__nfet_01v8 l=0.5 w=5
XM7 N12 LABEL_NET_3 N5 VDD sky130_fd_pr__pfet_01v8 l=0.5 w=5
XM8 N12 N4 N7 GND sky130_fd_pr__nfet_01v8 l=0.5 w=5
I2 N6 N0 1u
XM9 N8 N7 N3 GND sky130_fd_pr__nfet_01v8 l=0.5 w=5
XM10 N7 N2 N3 GND sky130_fd_pr__nfet_01v8 l=0.5 w=5
I3 N6 N5 1u
XM11 N7 N9 N12 VDD sky130_fd_pr__pfet_01v8 l=0.5 w=5
XM12 N9 N9 N11 VDD sky130_fd_pr__pfet_01v8 l=0.5 w=5
I4 N9 N3 1u
I5 N1 N3 1u

.control
set filetype=ascii

op
let power_dc = abs(i(VVDD)) * 1.8
print power_dc

ac dec 100 1 10g
let vout_mag = vm(N10)
let gain_db = db(vout_mag)
let dc_gain_db = gain_db[0]
print dc_gain_db

if dc_gain_db > 0
    meas ac ugbw WHEN gain_db=0 CROSS=1
    print ugbw
end

quit
.endc

.end
