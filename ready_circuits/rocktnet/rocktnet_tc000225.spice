* Testcase 000225 — Full Analysis (sky130 tt corner)
* SKY130 model header — replaces the ideal level-1 .model cards
* Ships with the demo; the paths point at the local sky130 PDK checkout.
* NOTE: libs.tech/ngspice/all.spice sets ".option scale=1.0u", so every
* instance L/W below is written in microns WITHOUT a "u" suffix.
.param mc_mm_switch=0
.param mc_pr_switch=0
.include /home/idies/workspace/Temporary/xyu1/scratch/skywater-pdk-libs-sky130_fd_pr/models/corners/tt.spice
.include /home/idies/workspace/Temporary/xyu1/scratch/skywater-pdk-libs-sky130_fd_pr/models/r+c/res_typical__cap_typical.spice
.include /home/idies/workspace/Temporary/xyu1/scratch/skywater-pdk-libs-sky130_fd_pr/models/r+c/res_typical__cap_typical__lin.spice
.include /home/idies/workspace/Temporary/xyu1/scratch/skywater-pdk-libs-sky130_fd_pr/models/corners/tt/specialized_cells.spice
.model DIDEAL D   is=1e-14 n=1
.options reltol=1e-3 itl1=500 itl2=100

* Sources
VVDD VDD 0 1.8
VVCTRL VCTRL 0 DC 0.9 AC 0.5

* Circuit
XMN1 B PULSE2 GND GND sky130_fd_pr__nfet_01v8 l=0.5 w=5
XMP2 VCTRL VQP A VDD sky130_fd_pr__pfet_01v8 l=0.5 w=5
XMN2 VCTRL VQN B GND sky130_fd_pr__nfet_01v8 l=0.5 w=5
XMP1 A PULSE1 VDD VDD sky130_fd_pr__pfet_01v8 l=0.5 w=5
XMNS A PULSE1 GND GND sky130_fd_pr__nfet_01v8 l=0.5 w=5
XMPS B PULSE2 VDD VDD sky130_fd_pr__pfet_01v8 l=0.5 w=5
C VCTRL GND 1p

.control
set filetype=ascii

op
let vdd_current = abs(i(VVDD))
let power_dc = vdd_current * 1.8
print power_dc

ac dec 100 1 10g
let vout_mag = vm(VCTRL)
let gain_db = db(vout_mag)
let dc_gain_db = gain_db[0]
print dc_gain_db

if dc_gain_db > 0
    meas ac ugbw WHEN gain_db=0 CROSS=1
end

quit
.endc

.end
