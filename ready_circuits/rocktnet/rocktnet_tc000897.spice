* Testcase 000897 — Full Analysis (sky130 tt corner)
* SKY130 model header — replaces the ideal level-1 .model cards
* Ships with the demo; the paths point at the local sky130 PDK checkout.
* NOTE: libs.tech/ngspice/all.spice sets ".option scale=1.0u", so every
* instance L/W below is written in microns WITHOUT a "u" suffix.
.param mc_mm_switch=0
.param mc_pr_switch=0
.include /home/idies/workspace/Temporary/xyu1/scratch/skywater-pdk-libs-sky130_fd_pr/models/corners/tt.spice
.include /home/idies/workspace/Temporary/xyu1/scratch/skywater-pdk-libs-sky130_fd_pr/models/r+c/res_typical__cap_typical.spice
.include /home/idies/workspace/Temporary/xyu1/scratch/skywater-pdk-libs-sky130_fd_pr/models/r+c/res_typical__cap_typical__lin.spice
.include /home/idies/workspace/Temporary/xyu1/scratch/skywater-pdk-libs-sky130_fd_pr/models/corners/tt/specialized_cells.spice
.model DIDEAL D   is=1e-14 n=1
.options reltol=1e-3 itl1=500 itl2=100

* Sources
VIN IN 0 DC 0.9 AC 1 SIN(0.9 0.1 1MEG 0 0)

* Circuit
R1 N4 VCC 10k
R2 N4 N17 10k
R3 VCC N9 10k
R4 VCC QN 10k
R5 Q VCC 10k
R6 N0 VEE 10k
R7 VCC N12 10k
R8 N13 VEE 10k
R9 VEE N18 10k
R10 VEE N20 10k
R11 VCC N10 10k
R12 N5 VEE 10k
R13 N11 VEE 10k
R14 N15 VEE 10k
R15 N1 VEE 10k
R16 N8 VEE 10k
R17 N2 VEE 10k
R18 N4 IOUT 10k
XQ1 N19 N10 N20 0 sky130_fd_pr__npn_05v5_W1p00L1p00
XQ2 N14 N17 N13 0 sky130_fd_pr__npn_05v5_W1p00L1p00
XQ3 N17 N17 N18 0 sky130_fd_pr__npn_05v5_W1p00L1p00
XQ4 VCC IN N5 0 sky130_fd_pr__npn_05v5_W1p00L1p00
XQ5 N10 N10 N15 0 sky130_fd_pr__npn_05v5_W1p00L1p00
XQ6 VCC I N0 0 sky130_fd_pr__npn_05v5_W1p00L1p00
XQ7 VCC N1 N11 0 sky130_fd_pr__npn_05v5_W1p00L1p00
XQ8 Q N8 N14 0 sky130_fd_pr__npn_05v5_W1p00L1p00
XQ9 VCC N9 N1 0 sky130_fd_pr__npn_05v5_W1p00L1p00
XQ10 VCC N2 N8 0 sky130_fd_pr__npn_05v5_W1p00L1p00
XQ11 VCC N12 N2 0 sky130_fd_pr__npn_05v5_W1p00L1p00
XQ12 QN N11 N14 0 sky130_fd_pr__npn_05v5_W1p00L1p00
XQ13 N12 N0 N19 0 sky130_fd_pr__npn_05v5_W1p00L1p00
XQ14 N9 N5 N19 0 sky130_fd_pr__npn_05v5_W1p00L1p00

.control
set filetype=ascii

op
let power_dc = abs(i(VIN)) * 1.8
print power_dc
let dc_voltage = v(IOUT)
print dc_voltage

quit
.endc

.end
