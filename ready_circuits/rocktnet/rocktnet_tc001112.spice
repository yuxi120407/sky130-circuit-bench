* Testcase 001112 — Full Analysis (sky130 tt corner)
* SKY130 model header — replaces the ideal level-1 .model cards
* Ships with the demo; the paths point at the local sky130 PDK checkout.
* NOTE: libs.tech/ngspice/all.spice sets ".option scale=1.0u", so every
* instance L/W below is written in microns WITHOUT a "u" suffix.
.param mc_mm_switch=0
.param mc_pr_switch=0
.include /home/idies/workspace/Temporary/xyu1/scratch/skywater-pdk-libs-sky130_fd_pr/models/corners/tt.spice
.include /home/idies/workspace/Temporary/xyu1/scratch/skywater-pdk-libs-sky130_fd_pr/models/r+c/res_typical__cap_typical.spice
.include /home/idies/workspace/Temporary/xyu1/scratch/skywater-pdk-libs-sky130_fd_pr/models/r+c/res_typical__cap_typical__lin.spice
.include /home/idies/workspace/Temporary/xyu1/scratch/skywater-pdk-libs-sky130_fd_pr/models/corners/tt/specialized_cells.spice
.model DIDEAL D   is=1e-14 n=1
.options reltol=1e-3 itl1=500 itl2=100

* Sources
VIN IN 0 DC 0.9 AC 1 SIN(0.9 0.1 1MEG 0 0)
VIN_BAR IN_BAR 0 DC 0.9 AC 1 SIN(0.9 0.1 1MEG 0 0)
VIBIAS IBIAS 0 0.75

* Circuit
XM1 N1 IN N3 VEE sky130_fd_pr__nfet_01v8 l=0.5 w=5
XM2 N2 IN_BAR N3 VEE sky130_fd_pr__nfet_01v8 l=0.5 w=5
XM4 N8 N5 N10 VEE sky130_fd_pr__nfet_01v8 l=0.5 w=5
XM3 N9 N7 N10 VEE sky130_fd_pr__nfet_01v8 l=0.5 w=5
XQ4 VCC_CP N1 N4 0 sky130_fd_pr__npn_05v5_W1p00L1p00
XQ2 VCC_CP N2 N6 0 sky130_fd_pr__npn_05v5_W1p00L1p00
XQ6 VCC_CP N4 N5 0 sky130_fd_pr__npn_05v5_W1p00L1p00
XQ8 VCC_CP N6 N7 0 sky130_fd_pr__npn_05v5_W1p00L1p00
XQ9 VCC N8 N11 0 sky130_fd_pr__npn_05v5_W1p00L1p00
XQ7 VCC N9 N12 0 sky130_fd_pr__npn_05v5_W1p00L1p00
XQ5 OUT N11 N13 0 sky130_fd_pr__npn_05v5_W1p00L1p00
XQ1 OUT_BAR N12 N13 0 sky130_fd_pr__npn_05v5_W1p00L1p00
XQ17 N3 IBIAS N14 0 sky130_fd_pr__npn_05v5_W1p00L1p00
XQ16 N4 IBIAS N15 0 sky130_fd_pr__npn_05v5_W1p00L1p00
XQ11 N5 IBIAS N16 0 sky130_fd_pr__npn_05v5_W1p00L1p00
XQ14 N6 IBIAS N17 0 sky130_fd_pr__npn_05v5_W1p00L1p00
XQ15 N7 IBIAS N18 0 sky130_fd_pr__npn_05v5_W1p00L1p00
XQ12 N10 IBIAS N19 0 sky130_fd_pr__npn_05v5_W1p00L1p00
XQ13 N11 IBIAS N20 0 sky130_fd_pr__npn_05v5_W1p00L1p00
XQ3 N12 IBIAS N21 0 sky130_fd_pr__npn_05v5_W1p00L1p00
XQ10 N13 IBIAS N22 0 sky130_fd_pr__npn_05v5_W1p00L1p00
R9 VCC_CP N1 10k
R5 VCC_CP N2 10k
R6 VCC N8 10k
R2 VCC N9 10k
R8 VCC OUT 10k
R3 VCC OUT_BAR 10k
R13 N14 VEE 10k
R12 N15 VEE 10k
R15 N16 VEE 10k
R10 N17 VEE 10k
R7 N18 VEE 10k
R1 N19 VEE 10k
R4 N20 VEE 10k
R14 N21 VEE 10k
R11 N22 VEE 10k

.control
set filetype=ascii

op
let vdd_current = abs(i(VVDD))
let power_dc = vdd_current * 1.8
print power_dc

ac dec 100 1 10g
let vout_mag = vm(OUT)
let gain_db = db(vout_mag)
let dc_gain_db = gain_db[0]
print dc_gain_db

if dc_gain_db > 0
    meas ac ugbw WHEN gain_db=0 CROSS=1
end

quit
.endc

.end
