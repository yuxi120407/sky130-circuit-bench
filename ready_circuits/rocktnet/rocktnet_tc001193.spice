* Testcase 001193 — Full Analysis (sky130 tt corner)
* SKY130 model header — replaces the ideal level-1 .model cards
* Ships with the demo; the paths point at the local sky130 PDK checkout.
* NOTE: libs.tech/ngspice/all.spice sets ".option scale=1.0u", so every
* instance L/W below is written in microns WITHOUT a "u" suffix.
.param mc_mm_switch=0
.param mc_pr_switch=0
.include /home/idies/workspace/Temporary/xyu1/scratch/skywater-pdk-libs-sky130_fd_pr/models/corners/tt.spice
.include /home/idies/workspace/Temporary/xyu1/scratch/skywater-pdk-libs-sky130_fd_pr/models/r+c/res_typical__cap_typical.spice
.include /home/idies/workspace/Temporary/xyu1/scratch/skywater-pdk-libs-sky130_fd_pr/models/r+c/res_typical__cap_typical__lin.spice
.include /home/idies/workspace/Temporary/xyu1/scratch/skywater-pdk-libs-sky130_fd_pr/models/corners/tt/specialized_cells.spice
.model DIDEAL D   is=1e-14 n=1
.options reltol=1e-3 itl1=500 itl2=100

* Sources
VVDD VDD 0 1.8
VVCM VCM 0 DC 0.9 AC 0.5

* Circuit
XM1 N0 VCM N2 GND sky130_fd_pr__nfet_01v8 l=0.5 w=5
XM2 VOM N4 N1 GND sky130_fd_pr__nfet_01v8 l=0.5 w=5
XM3 N4 N11 N1 GND sky130_fd_pr__nfet_01v8 l=0.5 w=5
XM4 N2 N1 N1 GND sky130_fd_pr__nfet_01v8 l=0.5 w=5
XM5 N7 N11 N1 GND sky130_fd_pr__nfet_01v8 l=0.5 w=5
XM6 N4 VIM N6 VDD sky130_fd_pr__pfet_01v8 l=0.5 w=5
R1 N7 N10 10k
R2 N4 N9 10k
XM7 N7 VIP N6 VDD sky130_fd_pr__pfet_01v8 l=0.5 w=5
XM8 VOM N8 VDD VDD sky130_fd_pr__pfet_01v8 l=0.5 w=5
XM9 VDD VDD VDD VDD sky130_fd_pr__pfet_01v8 l=0.5 w=5
XM10 VDD VFCM N2 GND sky130_fd_pr__nfet_01v8 l=0.5 w=5
XM11 N6 VDD VDD VDD sky130_fd_pr__pfet_01v8 l=0.5 w=5
XM12 VOP N8 VDD VDD sky130_fd_pr__pfet_01v8 l=0.5 w=5
XM13 N0 N0 VDD VDD sky130_fd_pr__pfet_01v8 l=0.5 w=5
XM14 VOP N7 N1 GND sky130_fd_pr__nfet_01v8 l=0.5 w=5
C1 VOP N10 1p
C2 VOM N9 1p

.control
set filetype=ascii

op
let power_dc = abs(i(VVDD)) * 1.8
print power_dc

ac dec 100 1 10g
let vout_mag = vm(N2)
let gain_db = db(vout_mag)
let dc_gain_db = gain_db[0]
print dc_gain_db

if dc_gain_db > 0
    meas ac ugbw WHEN gain_db=0 CROSS=1
    print ugbw
end

quit
.endc

.end
