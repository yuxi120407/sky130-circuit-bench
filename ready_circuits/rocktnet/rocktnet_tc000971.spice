* Testcase 000971 — Full Analysis (sky130 tt corner)
* SKY130 model header — replaces the ideal level-1 .model cards
* Ships with the demo; the paths point at the local sky130 PDK checkout.
* NOTE: libs.tech/ngspice/all.spice sets ".option scale=1.0u", so every
* instance L/W below is written in microns WITHOUT a "u" suffix.
.param mc_mm_switch=0
.param mc_pr_switch=0
.include /home/idies/workspace/Temporary/xyu1/scratch/skywater-pdk-libs-sky130_fd_pr/models/corners/tt.spice
.include /home/idies/workspace/Temporary/xyu1/scratch/skywater-pdk-libs-sky130_fd_pr/models/r+c/res_typical__cap_typical.spice
.include /home/idies/workspace/Temporary/xyu1/scratch/skywater-pdk-libs-sky130_fd_pr/models/r+c/res_typical__cap_typical__lin.spice
.include /home/idies/workspace/Temporary/xyu1/scratch/skywater-pdk-libs-sky130_fd_pr/models/corners/tt/specialized_cells.spice
.model DIDEAL D   is=1e-14 n=1
.options reltol=1e-3 itl1=500 itl2=100

* Sources
VVDD VDD 0 1.8
VLABEL_NET_0 LABEL_NET_0 0 DC 0.9 AC 0.5
VLABEL_NET_1 LABEL_NET_1 0 DC 0.9 AC -0.5
VLABEL_NET_2 LABEL_NET_2 0 DC 0.9 AC 1
VLABEL_NET_3 LABEL_NET_3 0 0.9

* Circuit
I1 N8 N9 1u
XM1 N6 N2 N5 GND sky130_fd_pr__nfet_01v8 l=0.5 w=5
XM2 N12 LABEL_NET_0 GND GND sky130_fd_pr__nfet_01v8 l=0.5 w=5
XM3 N1 N0 N7 GND sky130_fd_pr__nfet_01v8 l=0.5 w=5
XM4 N3 N6 N7 GND sky130_fd_pr__nfet_01v8 l=0.5 w=5
I2 N12 GND 1u
XM6 N0 N4 N5 GND sky130_fd_pr__nfet_01v8 l=0.5 w=5
XM5 N11 N4 N12 GND sky130_fd_pr__nfet_01v8 l=0.5 w=5
XM7 N9 N2 N12 GND sky130_fd_pr__nfet_01v8 l=0.5 w=5
XM8 N1 N13 N10 VDD sky130_fd_pr__pfet_01v8 l=0.5 w=5
XM9 N5 LABEL_NET_1 GND GND sky130_fd_pr__nfet_01v8 l=0.5 w=5
XM10 N0 N14 VDD VDD sky130_fd_pr__pfet_01v8 l=0.5 w=5
XM11 N7 LABEL_NET_2 GND GND sky130_fd_pr__nfet_01v8 l=0.5 w=5
XM12 N8 LABEL_NET_3 N11 GND sky130_fd_pr__nfet_01v8 l=0.5 w=5
XM13 N8 LABEL_NET_3 N9 GND sky130_fd_pr__nfet_01v8 l=0.5 w=5
XM14 N6 N14 VDD VDD sky130_fd_pr__pfet_01v8 l=0.5 w=5
XM15 N3 N13 N10 VDD sky130_fd_pr__pfet_01v8 l=0.5 w=5
C1 N0 N1 1p
C2 N3 N6 1p
I3 N8 N11 1u

.control
set filetype=ascii

op
let power_dc = abs(i(VVDD)) * 1.8
print power_dc

ac dec 100 1 10g
let gain_N1 = db(vm(N1))
let gain_N7 = db(vm(N7))
let gain_N5 = db(vm(N5))
let gain_N6 = db(vm(N6))
let gain_N4 = db(vm(N4))
meas ac max_gain_N1 MAX gain_N1
meas ac max_gain_N7 MAX gain_N7
meas ac max_gain_N5 MAX gain_N5
meas ac max_gain_N6 MAX gain_N6
meas ac max_gain_N4 MAX gain_N4

* Use first probe node for standard metrics
let gain_db = db(vm(N1))
meas ac dc_gain_db FIND gain_db AT=1
meas ac ugbw WHEN gain_db=0 CROSS=1
let vout_dc = v(N1)

print dc_gain_db ugbw vout_dc gain_N1 gain_N7 gain_N5 gain_N6 gain_N4

quit
.endc

.end
