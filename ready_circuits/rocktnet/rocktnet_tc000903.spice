* Testcase 000903 — Full Analysis (sky130 tt corner)
* SKY130 model header — replaces the ideal level-1 .model cards
* Ships with the demo; the paths point at the local sky130 PDK checkout.
* NOTE: libs.tech/ngspice/all.spice sets ".option scale=1.0u", so every
* instance L/W below is written in microns WITHOUT a "u" suffix.
.param mc_mm_switch=0
.param mc_pr_switch=0
.include /home/idies/workspace/Temporary/xyu1/scratch/skywater-pdk-libs-sky130_fd_pr/models/corners/tt.spice
.include /home/idies/workspace/Temporary/xyu1/scratch/skywater-pdk-libs-sky130_fd_pr/models/r+c/res_typical__cap_typical.spice
.include /home/idies/workspace/Temporary/xyu1/scratch/skywater-pdk-libs-sky130_fd_pr/models/r+c/res_typical__cap_typical__lin.spice
.include /home/idies/workspace/Temporary/xyu1/scratch/skywater-pdk-libs-sky130_fd_pr/models/corners/tt/specialized_cells.spice
.model DIDEAL D   is=1e-14 n=1
.options reltol=1e-3 itl1=500 itl2=100

* Sources
VLABEL_NET_0 LABEL_NET_0 0 DC 0.9 AC 0.5

* Circuit
R1 N1 N10 10k
XQ1 N12 N8 N4 0 sky130_fd_pr__npn_05v5_W1p00L1p00
XQ2 N1 N7 GND 0 sky130_fd_pr__npn_05v5_W1p00L1p00
XQ3 N2 N11 GND 0 sky130_fd_pr__npn_05v5_W1p00L1p00
R2 N10 N12 10k
C1 N3 N5 1p
R3 N2 N10 10k
XQ4 N9 N6 N4 0 sky130_fd_pr__npn_05v5_W1p00L1p00
C2 N0 N11 1p
L1 N3 N5 10n
L2 N5 N7 10n
R4 N4 GND 10k
R5 N9 N10 10k
C3 N5 GND 1p
C4 N7 GND 1p
L3 N0 N11 10n
C5 N11 N13 1p
C6 N1 N8 1p
L4 N5 N11 10n
C7 N2 N6 1p
C8 N5 LABEL_NET_0 1p
C9 N11 N13 1p

.control
set filetype=ascii

op
let vdd_current = abs(i(VVDD))
let power_dc = vdd_current * 1.8
print power_dc

ac dec 100 1k 100g
let vout_mag = vm(N4)
let gain_db = db(vout_mag)

meas ac max_gain_db MAX gain_db
meas ac bw_3db WHEN gain_db='max_gain_db-3' CROSS=1

print max_gain_db bw_3db

quit
.endc

.end
