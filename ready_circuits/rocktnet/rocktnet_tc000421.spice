* Testcase 000421 — Full Analysis (sky130 tt corner)
* SKY130 model header — replaces the ideal level-1 .model cards
* Ships with the demo; the paths point at the local sky130 PDK checkout.
* NOTE: libs.tech/ngspice/all.spice sets ".option scale=1.0u", so every
* instance L/W below is written in microns WITHOUT a "u" suffix.
.param mc_mm_switch=0
.param mc_pr_switch=0
.include /home/idies/workspace/Temporary/xyu1/scratch/skywater-pdk-libs-sky130_fd_pr/models/corners/tt.spice
.include /home/idies/workspace/Temporary/xyu1/scratch/skywater-pdk-libs-sky130_fd_pr/models/r+c/res_typical__cap_typical.spice
.include /home/idies/workspace/Temporary/xyu1/scratch/skywater-pdk-libs-sky130_fd_pr/models/r+c/res_typical__cap_typical__lin.spice
.include /home/idies/workspace/Temporary/xyu1/scratch/skywater-pdk-libs-sky130_fd_pr/models/corners/tt/specialized_cells.spice
.model DIDEAL D   is=1e-14 n=1
.options reltol=1e-3 itl1=500 itl2=100

* Sources
VVIN VIN 0 DC 0.9 AC 1 SIN(0.9 0.1 1MEG 0 0)
VVINB VINB 0 DC 0.9 AC 1 SIN(0.9 0.1 1MEG 0 0)

* Circuit
XQ1 N1 VIN N3 0 sky130_fd_pr__npn_05v5_W1p00L1p00
XQ2 N2 VINB N4 0 sky130_fd_pr__npn_05v5_W1p00L1p00
XQ3 VOB LO N1 0 sky130_fd_pr__npn_05v5_W1p00L1p00
XQ4 VO LOB N1 0 sky130_fd_pr__npn_05v5_W1p00L1p00
XQ5 VOB LOB N2 0 sky130_fd_pr__npn_05v5_W1p00L1p00
XQ6 VO LO N2 0 sky130_fd_pr__npn_05v5_W1p00L1p00
R1 VCC VOB 10k
R2 VCC VO 10k
R3 N4 N5 10k
R4 N3 N5 10k
C1 VO VCC 1p
C2 VOB VCC 1p
I N5 VEE 1u

.control
set filetype=ascii

op
let vdd_current = abs(i(VVDD))
let power_dc = vdd_current * 1.8
print power_dc

ac dec 100 1 10g
let vout_mag = vm(VO)
let gain_db = db(vout_mag)
let dc_gain_db = gain_db[0]
print dc_gain_db

if dc_gain_db > 0
    meas ac ugbw WHEN gain_db=0 CROSS=1
end

quit
.endc

.end
