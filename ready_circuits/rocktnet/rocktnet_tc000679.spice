* Testcase 000679 — Full Analysis (sky130 tt corner)
* SKY130 model header — replaces the ideal level-1 .model cards
* Ships with the demo; the paths point at the local sky130 PDK checkout.
* NOTE: libs.tech/ngspice/all.spice sets ".option scale=1.0u", so every
* instance L/W below is written in microns WITHOUT a "u" suffix.
.param mc_mm_switch=0
.param mc_pr_switch=0
.include /home/idies/workspace/Temporary/xyu1/scratch/skywater-pdk-libs-sky130_fd_pr/models/corners/tt.spice
.include /home/idies/workspace/Temporary/xyu1/scratch/skywater-pdk-libs-sky130_fd_pr/models/r+c/res_typical__cap_typical.spice
.include /home/idies/workspace/Temporary/xyu1/scratch/skywater-pdk-libs-sky130_fd_pr/models/r+c/res_typical__cap_typical__lin.spice
.include /home/idies/workspace/Temporary/xyu1/scratch/skywater-pdk-libs-sky130_fd_pr/models/corners/tt/specialized_cells.spice
.model DIDEAL D   is=1e-14 n=1
.options reltol=1e-3 itl1=500 itl2=100

* Sources
VVDD VDD 0 1.8
VLABEL_NET_0 LABEL_NET_0 0 0.9
VVBN VBN 0 DC 0.54 AC 1
VLABEL_NET_1 LABEL_NET_1 0 0.9
VLABEL_NET_2 LABEL_NET_2 0 0.9

* Circuit
XM4 N5 N5 N6 VDD sky130_fd_pr__pfet_01v8 l=0.5 w=5
XM5 N2 N6 LABEL_NET_0 VDD sky130_fd_pr__pfet_01v8 l=0.5 w=5
XMBC N2 N2 GND GND sky130_fd_pr__nfet_01v8 l=0.5 w=5
XM3 VBN N5 LABEL_NET_1 VDD sky130_fd_pr__pfet_01v8 l=0.5 w=5
XM1C VGS2 N3 N4 GND sky130_fd_pr__nfet_01v8 l=0.5 w=5
R VGS2 VBN 10k
XM2 N7 LABEL_NET_2 GND GND sky130_fd_pr__nfet_01v8 l=0.5 w=5
XM2C N5 N3 N7 GND sky130_fd_pr__nfet_01v8 l=0.5 w=5
XM1 N4 VBN GND GND sky130_fd_pr__nfet_01v8 l=0.5 w=5

.control
set filetype=ascii

op
let power_dc = abs(i(VVDD)) * 1.8
print power_dc

ac dec 100 1 10g
let gain_N2 = db(vm(N2))
let gain_N5 = db(vm(N5))
let gain_N6 = db(vm(N6))
let gain_VGS2 = db(vm(VGS2))
let gain_N4 = db(vm(N4))
meas ac max_gain_N2 MAX gain_N2
meas ac max_gain_N5 MAX gain_N5
meas ac max_gain_N6 MAX gain_N6
meas ac max_gain_VGS2 MAX gain_VGS2
meas ac max_gain_N4 MAX gain_N4

* Use first probe node for standard metrics
let gain_db = db(vm(N2))
meas ac dc_gain_db FIND gain_db AT=1
meas ac ugbw WHEN gain_db=0 CROSS=1
let vout_dc = v(N2)

print dc_gain_db ugbw vout_dc gain_N2 gain_N5 gain_N6 gain_VGS2 gain_N4

quit
.endc

.end
