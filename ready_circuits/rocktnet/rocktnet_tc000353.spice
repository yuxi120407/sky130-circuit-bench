* Testcase 000353 — Full Analysis (sky130 tt corner)
* SKY130 model header — replaces the ideal level-1 .model cards
* Ships with the demo; the paths point at the local sky130 PDK checkout.
* NOTE: libs.tech/ngspice/all.spice sets ".option scale=1.0u", so every
* instance L/W below is written in microns WITHOUT a "u" suffix.
.param mc_mm_switch=0
.param mc_pr_switch=0
.include /home/idies/workspace/Temporary/xyu1/scratch/skywater-pdk-libs-sky130_fd_pr/models/corners/tt.spice
.include /home/idies/workspace/Temporary/xyu1/scratch/skywater-pdk-libs-sky130_fd_pr/models/r+c/res_typical__cap_typical.spice
.include /home/idies/workspace/Temporary/xyu1/scratch/skywater-pdk-libs-sky130_fd_pr/models/r+c/res_typical__cap_typical__lin.spice
.include /home/idies/workspace/Temporary/xyu1/scratch/skywater-pdk-libs-sky130_fd_pr/models/corners/tt/specialized_cells.spice
.model DIDEAL D   is=1e-14 n=1
.options reltol=1e-3 itl1=500 itl2=100

* Sources
VVDD VDD 0 1.8
VLABEL_NET_3 LABEL_NET_3 0 DC 0.9 AC 0.5
VLABEL_NET_5 LABEL_NET_5 0 DC 0.9 AC -0.5
VLABEL_NET_6 LABEL_NET_6 0 0.9
VLABEL_NET_7 LABEL_NET_7 0 0.9

* Circuit
XQ1 N23 N23 N25 0 sky130_fd_pr__npn_05v5_W1p00L1p00
XQ2 N23 N1 N0 0 sky130_fd_pr__npn_05v5_W1p00L1p00
XM1 N0 N26 N26 GND sky130_fd_pr__nfet_01v8 l=0.5 w=5
XM2 N25 N26 N0 GND sky130_fd_pr__nfet_01v8 l=0.5 w=5
XQ3 N11 N20 N2 sky130_fd_pr__pnp_05v5_W3p40L3p40
XM3 N16 N2 N27 VDD sky130_fd_pr__pfet_01v8 l=0.5 w=5
XM4 N3 N27 N16 VDD sky130_fd_pr__pfet_01v8 l=0.5 w=5
XQ4 N12 N12 N14 0 sky130_fd_pr__npn_05v5_W1p00L1p00
XQ5 N12 N10 N4 0 sky130_fd_pr__npn_05v5_W1p00L1p00
XM5 N14 LABEL_NET_3 N0 GND sky130_fd_pr__nfet_01v8 l=0.5 w=5
R1 N6 N21 10k
R2 N9 N10 10k
C1 N13 N18 1p
XQ6 N16 N19 N3 sky130_fd_pr__pnp_05v5_W3p40L3p40
C2 N0 N6 1p
R3 N9 N21 10k
XM6 N2 LABEL_NET_5 N16 VDD sky130_fd_pr__pfet_01v8 l=0.5 w=5
R4 N5 N15 10k
C3 N5 N22 1p
XM7 N4 LABEL_NET_6 N14 GND sky130_fd_pr__nfet_01v8 l=0.5 w=5
R5 N1 N6 10k
XM8 N11 LABEL_NET_7 N2 VDD sky130_fd_pr__pfet_01v8 l=0.5 w=5
C4 N4 N24 1p
C5 N8 N16 1p
R6 N7 N8 10k
R7 N13 N14 10k
C6 N11 N15 1p
R8 N17 N25 10k
XQ7 N20 N5 N11 sky130_fd_pr__pnp_05v5_W3p40L3p40
R9 N8 N17 10k
XQ8 N19 N7 N16 sky130_fd_pr__pnp_05v5_W3p40L3p40
R10 N13 N15 10k
C7 N17 N18 1p
C8 N4 N9 1p
C9 N1 N24 1p
C10 N7 N22 1p

.control
set filetype=ascii

op
let power_dc = abs(i(VVDD)) * 1.8
print power_dc

ac dec 100 1 10g
let vout_mag = vm(N0)
let gain_db = db(vout_mag)
let dc_gain_db = gain_db[0]
print dc_gain_db

if dc_gain_db > 0
    meas ac ugbw WHEN gain_db=0 CROSS=1
    print ugbw
end

quit
.endc

.end
