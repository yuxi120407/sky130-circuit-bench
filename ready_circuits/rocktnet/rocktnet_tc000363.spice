* Testcase 000363 — Full Analysis (sky130 tt corner)
* SKY130 model header — replaces the ideal level-1 .model cards
* Ships with the demo; the paths point at the local sky130 PDK checkout.
* NOTE: libs.tech/ngspice/all.spice sets ".option scale=1.0u", so every
* instance L/W below is written in microns WITHOUT a "u" suffix.
.param mc_mm_switch=0
.param mc_pr_switch=0
.include /home/idies/workspace/Temporary/xyu1/scratch/skywater-pdk-libs-sky130_fd_pr/models/corners/tt.spice
.include /home/idies/workspace/Temporary/xyu1/scratch/skywater-pdk-libs-sky130_fd_pr/models/r+c/res_typical__cap_typical.spice
.include /home/idies/workspace/Temporary/xyu1/scratch/skywater-pdk-libs-sky130_fd_pr/models/r+c/res_typical__cap_typical__lin.spice
.include /home/idies/workspace/Temporary/xyu1/scratch/skywater-pdk-libs-sky130_fd_pr/models/corners/tt/specialized_cells.spice
.model DIDEAL D   is=1e-14 n=1
.options reltol=1e-3 itl1=500 itl2=100

* Sources
VVDD VDD 0 1.8
VIBIAS IBIAS 0 DC 0.9900000000000001 AC 0.5

* Circuit
XM1 VO_PLUS VO_MINUS GND GND sky130_fd_pr__nfet_01v8 l=0.5 w=5
I1 IBIAS GND 1u
XM2 VO_MINUS VO_PLUS GND GND sky130_fd_pr__nfet_01v8 l=0.5 w=5
XM3 N1 IBIAS VDD VDD sky130_fd_pr__pfet_01v8 l=0.5 w=5
XM4 VC VO_PLUS VC VC sky130_fd_pr__nfet_01v8 l=0.5 w=5
XM5 IBIAS IBIAS VDD VDD sky130_fd_pr__pfet_01v8 l=0.5 w=5
L1 VO_PLUS N1 10n
L2 N1 VO_MINUS 10n
XM6 VC VO_MINUS VC VC sky130_fd_pr__nfet_01v8 l=0.5 w=5

.control
set filetype=ascii

op
let power_dc = abs(i(VVDD)) * 1.8
print power_dc

ac dec 100 1 10g
let vout_mag = vm(N1)
let gain_db = db(vout_mag)
let dc_gain_db = gain_db[0]
print dc_gain_db

if dc_gain_db > 0
    meas ac ugbw WHEN gain_db=0 CROSS=1
    print ugbw
end

quit
.endc

.end
