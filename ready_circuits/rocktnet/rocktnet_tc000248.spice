* Testcase 000248 — Full Analysis (sky130 tt corner)
* SKY130 model header — replaces the ideal level-1 .model cards
* Ships with the demo; the paths point at the local sky130 PDK checkout.
* NOTE: libs.tech/ngspice/all.spice sets ".option scale=1.0u", so every
* instance L/W below is written in microns WITHOUT a "u" suffix.
.param mc_mm_switch=0
.param mc_pr_switch=0
.include /home/idies/workspace/Temporary/xyu1/scratch/skywater-pdk-libs-sky130_fd_pr/models/corners/tt.spice
.include /home/idies/workspace/Temporary/xyu1/scratch/skywater-pdk-libs-sky130_fd_pr/models/r+c/res_typical__cap_typical.spice
.include /home/idies/workspace/Temporary/xyu1/scratch/skywater-pdk-libs-sky130_fd_pr/models/r+c/res_typical__cap_typical__lin.spice
.include /home/idies/workspace/Temporary/xyu1/scratch/skywater-pdk-libs-sky130_fd_pr/models/corners/tt/specialized_cells.spice
.model DIDEAL D   is=1e-14 n=1
.options reltol=1e-3 itl1=500 itl2=100

* Sources
VIN IN 0 DC 0.9 AC 1 SIN(0.9 0.1 1MEG 0 0)
VVB VB 0 0.75

* Circuit
XQ1 N8 N6 N3 0 sky130_fd_pr__npn_05v5_W1p00L1p00
XQ2 GND REF N5 0 sky130_fd_pr__npn_05v5_W1p00L1p00
R1 N16 GND 50
R2 N17 n3.6V 50
R3 N15 n3.6V 50
XQ3 N1 N5 N11 0 sky130_fd_pr__npn_05v5_W1p00L1p00
R4 N1 GND 50
R5 N8 GND 50
R6 N20 n3.6V 50
R7 N10 n3.6V 50
R8 N9 n3.6V 50
XQ4 GND N1 N7 0 sky130_fd_pr__npn_05v5_W1p00L1p00
XQ5 N16 N7 N3 0 sky130_fd_pr__npn_05v5_W1p00L1p00
R9 REF GND 50
XQ6 N0 N12 N11 0 sky130_fd_pr__npn_05v5_W1p00L1p00
R10 N19 n3.6V 50
XQ7 GND N16 OUT2 0 sky130_fd_pr__npn_05v5_W1p00L1p00
R11 IN GND 50
R12 N0 GND 50
XQ8 GND N8 OUT1 0 sky130_fd_pr__npn_05v5_W1p00L1p00
XQ9 GND N0 N6 0 sky130_fd_pr__npn_05v5_W1p00L1p00
R13 N14 n3.6V 50
R14 N28 n3.6V 50
XQ10 N7 VB N17 0 sky130_fd_pr__npn_05v5_W1p00L1p00
XQ11 N11 VB N20 0 sky130_fd_pr__npn_05v5_W1p00L1p00
XQ12 OUT1 VB N9 0 sky130_fd_pr__npn_05v5_W1p00L1p00
XQ13 OUT2 VB N10 0 sky130_fd_pr__npn_05v5_W1p00L1p00
XQ14 N3 VB N14 0 sky130_fd_pr__npn_05v5_W1p00L1p00
XQ15 N6 VB N28 0 sky130_fd_pr__npn_05v5_W1p00L1p00
XQ16 GND IN N12 0 sky130_fd_pr__npn_05v5_W1p00L1p00
XQ17 N5 VB N15 0 sky130_fd_pr__npn_05v5_W1p00L1p00
XQ18 N12 VB N19 0 sky130_fd_pr__npn_05v5_W1p00L1p00

.control
set filetype=ascii

op
let vdd_current = abs(i(VVDD))
let power_dc = vdd_current * 1.8
print power_dc

ac dec 100 1 10g
let vout_mag = vm(N16)
let gain_db = db(vout_mag)
let dc_gain_db = gain_db[0]
print dc_gain_db

if dc_gain_db > 0
    meas ac ugbw WHEN gain_db=0 CROSS=1
end

quit
.endc

.end
