* Testcase 000290 — Full Analysis (sky130 tt corner)
* SKY130 model header — replaces the ideal level-1 .model cards
* Ships with the demo; the paths point at the local sky130 PDK checkout.
* NOTE: libs.tech/ngspice/all.spice sets ".option scale=1.0u", so every
* instance L/W below is written in microns WITHOUT a "u" suffix.
.param mc_mm_switch=0
.param mc_pr_switch=0
.include /home/idies/workspace/Temporary/xyu1/scratch/skywater-pdk-libs-sky130_fd_pr/models/corners/tt.spice
.include /home/idies/workspace/Temporary/xyu1/scratch/skywater-pdk-libs-sky130_fd_pr/models/r+c/res_typical__cap_typical.spice
.include /home/idies/workspace/Temporary/xyu1/scratch/skywater-pdk-libs-sky130_fd_pr/models/r+c/res_typical__cap_typical__lin.spice
.include /home/idies/workspace/Temporary/xyu1/scratch/skywater-pdk-libs-sky130_fd_pr/models/corners/tt/specialized_cells.spice
.model DIDEAL D   is=1e-14 n=1
.options reltol=1e-3 itl1=500 itl2=100

* Sources
VVDD VDD 0 1.8
VVB2 VB2 0 0.54
VVIN VIN 0 DC 0.9 AC 1 SIN(0.9 0.1 1MEG 0 0)
VVB1 VB1 0 0.75

* Circuit
L2 N3 N4 10n
L3 VDD N7 10n
XM3 N9 N0 N3 GND sky130_fd_pr__nfet_01v8 l=0.5 w=5
L4 VDD N2 10n
XM8 N1 LO_Q N6 GND sky130_fd_pr__nfet_01v8 l=0.5 w=5
L6 VDD N1 10n
L1 N5 GND 10n
XM2 N4 VB2 N11 GND sky130_fd_pr__nfet_01v8 l=0.5 w=5
XM4 N7 LO_I N9 GND sky130_fd_pr__nfet_01v8 l=0.5 w=5
L5 VDD N10 10n
XM6 N6 N0 N3 GND sky130_fd_pr__nfet_01v8 l=0.5 w=5
XM1 N11 VIN N5 GND sky130_fd_pr__nfet_01v8 l=0.5 w=5
XM7 N10 LO_Q_BAR N6 GND sky130_fd_pr__nfet_01v8 l=0.5 w=5
XM5 N2 LO_I_BAR N9 GND sky130_fd_pr__nfet_01v8 l=0.5 w=5
C1 N0 N4 1p
RB N0 VB1 10k
C2 N3 GND 1p

.control
set filetype=ascii

op
let vdd_current = abs(i(VVDD))
let power_dc = vdd_current * 1.8
print power_dc

ac dec 100 1k 100g
let vout_mag = vm(N3)
let gain_db = db(vout_mag)

meas ac max_gain_db MAX gain_db
meas ac bw_3db WHEN gain_db='max_gain_db-3' CROSS=1

print max_gain_db bw_3db

quit
.endc

.end
