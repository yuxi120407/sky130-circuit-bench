* Testcase 000163 — Full Analysis (sky130 tt corner)
* SKY130 model header — replaces the ideal level-1 .model cards
* Ships with the demo; the paths point at the local sky130 PDK checkout.
* NOTE: libs.tech/ngspice/all.spice sets ".option scale=1.0u", so every
* instance L/W below is written in microns WITHOUT a "u" suffix.
.param mc_mm_switch=0
.param mc_pr_switch=0
.include /home/idies/workspace/Temporary/xyu1/scratch/skywater-pdk-libs-sky130_fd_pr/models/corners/tt.spice
.include /home/idies/workspace/Temporary/xyu1/scratch/skywater-pdk-libs-sky130_fd_pr/models/r+c/res_typical__cap_typical.spice
.include /home/idies/workspace/Temporary/xyu1/scratch/skywater-pdk-libs-sky130_fd_pr/models/r+c/res_typical__cap_typical__lin.spice
.include /home/idies/workspace/Temporary/xyu1/scratch/skywater-pdk-libs-sky130_fd_pr/models/corners/tt/specialized_cells.spice
.model DIDEAL D   is=1e-14 n=1
.options reltol=1e-3 itl1=500 itl2=100

* Sources
VVDD VDD 0 1.8
VVB1 VB1 0 DC 0.9900000000000001 AC 0.5
VVB4 VB4 0 0.54
VVB3 VB3 0 0.54
VVB2 VB2 0 0.9900000000000001

* Circuit
XMP10B N6 VB1 VDD VDD sky130_fd_pr__pfet_01v8 l=0.5 w=5
XMN11B N5 VB4 GND GND sky130_fd_pr__nfet_01v8 l=0.5 w=5
XMN6B N1 VB3 N3 GND sky130_fd_pr__nfet_01v8 l=0.5 w=5
XMP8B N1 VB2 N6 VDD sky130_fd_pr__pfet_01v8 l=0.5 w=5
XMN1B N6 IAGND N5 GND sky130_fd_pr__nfet_01v8 l=0.5 w=5
XMN4B N3 N1 GND GND sky130_fd_pr__nfet_01v8 l=0.5 w=5
C3 N0 N10 1p
C2 FB OUTM 1p
C4 N0 N9 1p
C1 FB OUTP 1p

.control
set filetype=ascii

op
let vdd_current = abs(i(VVDD))
let power_dc = vdd_current * 1.8
print power_dc

ac dec 100 1 10g
let vout_mag = vm(OUTP)
let gain_db = db(vout_mag)
let dc_gain_db = gain_db[0]
print dc_gain_db

if dc_gain_db > 0
    meas ac ugbw WHEN gain_db=0 CROSS=1
end

quit
.endc

.end
