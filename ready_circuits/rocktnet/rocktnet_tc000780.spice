* Testcase 000780 — Full Analysis (sky130 tt corner)
* SKY130 model header — replaces the ideal level-1 .model cards
* Ships with the demo; the paths point at the local sky130 PDK checkout.
* NOTE: libs.tech/ngspice/all.spice sets ".option scale=1.0u", so every
* instance L/W below is written in microns WITHOUT a "u" suffix.
.param mc_mm_switch=0
.param mc_pr_switch=0
.include /home/idies/workspace/Temporary/xyu1/scratch/skywater-pdk-libs-sky130_fd_pr/models/corners/tt.spice
.include /home/idies/workspace/Temporary/xyu1/scratch/skywater-pdk-libs-sky130_fd_pr/models/r+c/res_typical__cap_typical.spice
.include /home/idies/workspace/Temporary/xyu1/scratch/skywater-pdk-libs-sky130_fd_pr/models/r+c/res_typical__cap_typical__lin.spice
.include /home/idies/workspace/Temporary/xyu1/scratch/skywater-pdk-libs-sky130_fd_pr/models/corners/tt/specialized_cells.spice
.model DIDEAL D   is=1e-14 n=1
.options reltol=1e-3 itl1=500 itl2=100

* Sources

* Circuit
R1 N10 N6 10k
R2 N7 VEE 10k
R3 N6 VEE 10k
R4 N4 VEE 10k
R5 GND N8 10k
R6 GND GND 10k
R7 GND VEE 10k
XQ1 N2 N5 N6 0 sky130_fd_pr__npn_05v5_W1p00L1p00
XQ2 GND N2 N0 0 sky130_fd_pr__npn_05v5_W1p00L1p00
XQ3 N8 GND N0 0 sky130_fd_pr__npn_05v5_W1p00L1p00
XQ4 GND GND N2 0 sky130_fd_pr__npn_05v5_W1p00L1p00
XQ5 GND N3 GND 0 sky130_fd_pr__npn_05v5_W1p00L1p00
XQ6 N3 CLK N4 0 sky130_fd_pr__npn_05v5_W1p00L1p00
XQ7 GND N8 N2 0 sky130_fd_pr__npn_05v5_W1p00L1p00
XQ8 N8 N8 GND 0 sky130_fd_pr__npn_05v5_W1p00L1p00
XQ9 GND N5 N10 0 sky130_fd_pr__npn_05v5_W1p00L1p00
XQ10 N0 GND N7 0 sky130_fd_pr__npn_05v5_W1p00L1p00
XQ11 N8 N0 GND sky130_fd_pr__pnp_05v5_W3p40L3p40

.control
set filetype=ascii

tran 0.1n 100n

let power = abs(i(VVDD)) * 1.8
let avg_power = mean(power)
print avg_power

meas tran vout_max MAX v(N8)
meas tran vout_min MIN v(N8)
let vout_swing = vout_max - vout_min
print vout_swing

quit
.endc

.end
