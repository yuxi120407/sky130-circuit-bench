* Testcase 001190 — Full Analysis (sky130 tt corner)
* SKY130 model header — replaces the ideal level-1 .model cards
* Ships with the demo; the paths point at the local sky130 PDK checkout.
* NOTE: libs.tech/ngspice/all.spice sets ".option scale=1.0u", so every
* instance L/W below is written in microns WITHOUT a "u" suffix.
.param mc_mm_switch=0
.param mc_pr_switch=0
.include /home/idies/workspace/Temporary/xyu1/scratch/skywater-pdk-libs-sky130_fd_pr/models/corners/tt.spice
.include /home/idies/workspace/Temporary/xyu1/scratch/skywater-pdk-libs-sky130_fd_pr/models/r+c/res_typical__cap_typical.spice
.include /home/idies/workspace/Temporary/xyu1/scratch/skywater-pdk-libs-sky130_fd_pr/models/r+c/res_typical__cap_typical__lin.spice
.include /home/idies/workspace/Temporary/xyu1/scratch/skywater-pdk-libs-sky130_fd_pr/models/corners/tt/specialized_cells.spice
.model DIDEAL D   is=1e-14 n=1
.options reltol=1e-3 itl1=500 itl2=100

* Sources
VVDD VDD 0 1.8
VVSS VSS 0 0
VINP INP 0 DC 0.9 AC 1 SIN(0.9 0.1 1MEG 0 0)
VINN INN 0 DC 0.9 AC 1 SIN(0.9 0.1 1MEG 0 0)

* Circuit
XM1 N4 INP N5 VDD sky130_fd_pr__pfet_01v8 l=0.5 w=5
XM2 N18 BIAS4 N2 VDD sky130_fd_pr__pfet_01v8 l=0.5 w=5
XM3 N19 N0 VDD VDD sky130_fd_pr__pfet_01v8 l=0.5 w=5
XM4 OUT N1 N19 VDD sky130_fd_pr__pfet_01v8 l=0.5 w=5
XM5 N1 N13 VDD VDD sky130_fd_pr__pfet_01v8 l=0.5 w=5
XM6 N0 N18 VDD VDD sky130_fd_pr__pfet_01v8 l=0.5 w=5
XM7 N12 N0 VSS VSS sky130_fd_pr__nfet_01v8 l=0.5 w=5
XM8 N3 BIAS3 N4 VSS sky130_fd_pr__nfet_01v8 l=0.5 w=5
XM9 N2 INN N8 VSS sky130_fd_pr__nfet_01v8 l=0.5 w=5
XM10 N7 BIAS2 VSS VSS sky130_fd_pr__nfet_01v8 l=0.5 w=5
XM11 N13 BIAS3 N7 VSS sky130_fd_pr__nfet_01v8 l=0.5 w=5
XM12 N3 N3 VDD VDD sky130_fd_pr__pfet_01v8 l=0.5 w=5
XM13 N5 BIAS1 VDD VDD sky130_fd_pr__pfet_01v8 l=0.5 w=5
XM14 N14 N14 VSS VSS sky130_fd_pr__nfet_01v8 l=0.5 w=5
XM15 N14 BIAS4 N15 VDD sky130_fd_pr__pfet_01v8 l=0.5 w=5
XM16 N4 BIAS2 VSS VSS sky130_fd_pr__nfet_01v8 l=0.5 w=5
XM17 OUT N1 N12 VSS sky130_fd_pr__nfet_01v8 l=0.5 w=5
XM18 N15 INP N8 VSS sky130_fd_pr__nfet_01v8 l=0.5 w=5
XM19 N0 N18 VSS VSS sky130_fd_pr__nfet_01v8 l=0.5 w=5
XM20 N13 N3 VDD VDD sky130_fd_pr__pfet_01v8 l=0.5 w=5
XM21 N18 N14 VSS VSS sky130_fd_pr__nfet_01v8 l=0.5 w=5
XM22 N2 BIAS1 VDD VDD sky130_fd_pr__pfet_01v8 l=0.5 w=5
XM23 N7 INN N5 VDD sky130_fd_pr__pfet_01v8 l=0.5 w=5
XM24 N8 BIAS2 VSS VSS sky130_fd_pr__nfet_01v8 l=0.5 w=5
XM25 N1 N13 VSS VSS sky130_fd_pr__nfet_01v8 l=0.5 w=5
XM26 N15 BIAS1 VDD VDD sky130_fd_pr__pfet_01v8 l=0.5 w=5
CC OUT N0 1p

.control
set filetype=ascii

op
let vdd_current = abs(i(VVDD))
let power_dc = vdd_current * 1.8
print power_dc

ac dec 100 1 10g
let vout_mag = vm(OUT)
let gain_db = db(vout_mag)
let dc_gain_db = gain_db[0]
print dc_gain_db

if dc_gain_db > 0
    meas ac ugbw WHEN gain_db=0 CROSS=1
end

quit
.endc

.end
