* Testcase 000743 — Full Analysis (sky130 tt corner)
* SKY130 model header — replaces the ideal level-1 .model cards
* Ships with the demo; the paths point at the local sky130 PDK checkout.
* NOTE: libs.tech/ngspice/all.spice sets ".option scale=1.0u", so every
* instance L/W below is written in microns WITHOUT a "u" suffix.
.param mc_mm_switch=0
.param mc_pr_switch=0
.include /home/idies/workspace/Temporary/xyu1/scratch/skywater-pdk-libs-sky130_fd_pr/models/corners/tt.spice
.include /home/idies/workspace/Temporary/xyu1/scratch/skywater-pdk-libs-sky130_fd_pr/models/r+c/res_typical__cap_typical.spice
.include /home/idies/workspace/Temporary/xyu1/scratch/skywater-pdk-libs-sky130_fd_pr/models/r+c/res_typical__cap_typical__lin.spice
.include /home/idies/workspace/Temporary/xyu1/scratch/skywater-pdk-libs-sky130_fd_pr/models/corners/tt/specialized_cells.spice
.model DIDEAL D   is=1e-14 n=1
.options reltol=1e-3 itl1=500 itl2=100

* Sources
VVDD VDD 0 1.8
VVBIAS VBIAS 0 0.54

* Circuit
XM1 VOP VGATE VDD VDD sky130_fd_pr__pfet_01v8 l=0.5 w=5
XM2 VON VGATE2 VDD VDD sky130_fd_pr__pfet_01v8 l=0.5 w=5
XM3 VOP D N_CS GND sky130_fd_pr__nfet_01v8 l=0.5 w=5
XM4 VON D_BAR N_CS GND sky130_fd_pr__nfet_01v8 l=0.5 w=5
XM5 N_CS VBIAS GND GND sky130_fd_pr__nfet_01v8 l=0.5 w=5
R1 VON VOCM 10k
R2 VOP VOCM 10k

.control
set filetype=ascii

op
let power_dc = abs(i(VVDD)) * 1.8
let vout_dc = v(N_CS)
print power_dc vout_dc

quit
.endc

.end
