* Testcase 001196 — Full Analysis (sky130 tt corner)
* SKY130 model header — replaces the ideal level-1 .model cards
* Ships with the demo; the paths point at the local sky130 PDK checkout.
* NOTE: libs.tech/ngspice/all.spice sets ".option scale=1.0u", so every
* instance L/W below is written in microns WITHOUT a "u" suffix.
.param mc_mm_switch=0
.param mc_pr_switch=0
.include /home/idies/workspace/Temporary/xyu1/scratch/skywater-pdk-libs-sky130_fd_pr/models/corners/tt.spice
.include /home/idies/workspace/Temporary/xyu1/scratch/skywater-pdk-libs-sky130_fd_pr/models/r+c/res_typical__cap_typical.spice
.include /home/idies/workspace/Temporary/xyu1/scratch/skywater-pdk-libs-sky130_fd_pr/models/r+c/res_typical__cap_typical__lin.spice
.include /home/idies/workspace/Temporary/xyu1/scratch/skywater-pdk-libs-sky130_fd_pr/models/corners/tt/specialized_cells.spice
.model DIDEAL D   is=1e-14 n=1
.options reltol=1e-3 itl1=500 itl2=100

* Sources
VVBB VBB 0 DC 0.75 AC 0.5

* Circuit
L1 VCC OUTn 10n
L2 VCC OUTp 10n
CR1 OUTn VTUNE 1p
CR2 OUTp VTUNE 1p
XQ1 OUTn VBB N_Q1 0 sky130_fd_pr__npn_05v5_W1p00L1p00
XQ2 OUTp VBB N_Q2 0 sky130_fd_pr__npn_05v5_W1p00L1p00
XQ3 N_Q1 N_BIAS VEE 0 sky130_fd_pr__npn_05v5_W1p00L1p00
XQ4 N_Q2 N_BIAS VEE 0 sky130_fd_pr__npn_05v5_W1p00L1p00
I1 VCC N_I1 1u
XQ5 VCC N_I1 N_BIAS 0 sky130_fd_pr__npn_05v5_W1p00L1p00
XQ6 N_I1 N_BIAS VEE 0 sky130_fd_pr__npn_05v5_W1p00L1p00
C1 N_Q1 VCC 2.793p
C2 N_Q2 VCC 2.793p
C3A N_Q1 N_Q2 2.497p
C3B N_Q1 N_Q2 2.497p

.control
set filetype=ascii

op
let vdd_current = abs(i(VVDD))
let power_dc = vdd_current * 1.8
print power_dc

ac dec 100 1k 100g
let vout_mag = vm(OUTp)
let gain_db = db(vout_mag)

meas ac max_gain_db MAX gain_db
meas ac bw_3db WHEN gain_db='max_gain_db-3' CROSS=1

print max_gain_db bw_3db

quit
.endc

.end
