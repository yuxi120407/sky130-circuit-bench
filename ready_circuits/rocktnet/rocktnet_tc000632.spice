* Testcase 000632 — Full Analysis (sky130 tt corner)
* SKY130 model header — replaces the ideal level-1 .model cards
* Ships with the demo; the paths point at the local sky130 PDK checkout.
* NOTE: libs.tech/ngspice/all.spice sets ".option scale=1.0u", so every
* instance L/W below is written in microns WITHOUT a "u" suffix.
.param mc_mm_switch=0
.param mc_pr_switch=0
.include /home/idies/workspace/Temporary/xyu1/scratch/skywater-pdk-libs-sky130_fd_pr/models/corners/tt.spice
.include /home/idies/workspace/Temporary/xyu1/scratch/skywater-pdk-libs-sky130_fd_pr/models/r+c/res_typical__cap_typical.spice
.include /home/idies/workspace/Temporary/xyu1/scratch/skywater-pdk-libs-sky130_fd_pr/models/r+c/res_typical__cap_typical__lin.spice
.include /home/idies/workspace/Temporary/xyu1/scratch/skywater-pdk-libs-sky130_fd_pr/models/corners/tt/specialized_cells.spice
.model DIDEAL D   is=1e-14 n=1
.options reltol=1e-3 itl1=500 itl2=100

* Sources
VVDD VDD 0 1.8
VLABEL_NET_0 LABEL_NET_0 0 0.9
VLABEL_NET_1 LABEL_NET_1 0 0.9
VLABEL_NET_2 LABEL_NET_2 0 0.9
VLABEL_NET_3 LABEL_NET_3 0 0.9
VLABEL_NET_4 LABEL_NET_4 0 0.9
VLABEL_NET_6 LABEL_NET_6 0 0.9

* Circuit
R1 N10 GND 10k
XM1 N12 LABEL_NET_1 N9 GND sky130_fd_pr__nfet_01v8 l=0.5 w=5
XM2 N11 N10 N10 GND sky130_fd_pr__nfet_01v8 l=0.5 w=5
XM3 N2 N2 GND GND sky130_fd_pr__nfet_01v8 l=0.5 w=5
R2 N8 LABEL_NET_2 10k
XM4 N2 N11 LABEL_NET_3 VDD sky130_fd_pr__pfet_01v8 l=0.5 w=5
XM5 N5 N7 GND GND sky130_fd_pr__nfet_01v8 l=0.5 w=5
XM6 N14 N6 N1 GND sky130_fd_pr__nfet_01v8 l=0.5 w=5
XM7 N1 N2 GND GND sky130_fd_pr__nfet_01v8 l=0.5 w=5
XM8 N8 N4 N13 GND sky130_fd_pr__nfet_01v8 l=0.5 w=5
XM9 N15 N5 N9 GND sky130_fd_pr__nfet_01v8 l=0.5 w=5
R3 N8 LABEL_NET_4 10k
XM10 N8 N3 N15 GND sky130_fd_pr__nfet_01v8 l=0.5 w=5
XM11 N8 N0 N12 GND sky130_fd_pr__nfet_01v8 l=0.5 w=5
XM12 N11 N11 N2 VDD sky130_fd_pr__pfet_01v8 l=0.5 w=5
XM13 N8 N3 N14 GND sky130_fd_pr__nfet_01v8 l=0.5 w=5
XM14 N1 N5 N9 GND sky130_fd_pr__nfet_01v8 l=0.5 w=5
XM15 N9 N6 N1 GND sky130_fd_pr__nfet_01v8 l=0.5 w=5
XM16 N13 N3 N14 GND sky130_fd_pr__nfet_01v8 l=0.5 w=5
XM17 N12 N3 N15 GND sky130_fd_pr__nfet_01v8 l=0.5 w=5
XM18 N15 N0 N12 GND sky130_fd_pr__nfet_01v8 l=0.5 w=5
XM19 N14 N4 N13 GND sky130_fd_pr__nfet_01v8 l=0.5 w=5
XM20 N13 LABEL_NET_6 N1 GND sky130_fd_pr__nfet_01v8 l=0.5 w=5

.control
set filetype=ascii

op
let vdd_current = abs(i(VVDD))
let power_dc = vdd_current * 1.8
let vout_dc = v(N10)
print power_dc vout_dc

quit
.endc

.end
