* Testcase 000861 — Full Analysis (sky130 tt corner)
* SKY130 model header — replaces the ideal level-1 .model cards
* Ships with the demo; the paths point at the local sky130 PDK checkout.
* NOTE: libs.tech/ngspice/all.spice sets ".option scale=1.0u", so every
* instance L/W below is written in microns WITHOUT a "u" suffix.
.param mc_mm_switch=0
.param mc_pr_switch=0
.include /home/idies/workspace/Temporary/xyu1/scratch/skywater-pdk-libs-sky130_fd_pr/models/corners/tt.spice
.include /home/idies/workspace/Temporary/xyu1/scratch/skywater-pdk-libs-sky130_fd_pr/models/r+c/res_typical__cap_typical.spice
.include /home/idies/workspace/Temporary/xyu1/scratch/skywater-pdk-libs-sky130_fd_pr/models/r+c/res_typical__cap_typical__lin.spice
.include /home/idies/workspace/Temporary/xyu1/scratch/skywater-pdk-libs-sky130_fd_pr/models/corners/tt/specialized_cells.spice
.model DIDEAL D   is=1e-14 n=1
.options reltol=1e-3 itl1=500 itl2=100

* Sources
VVDD VDD 0 1.8
VIN IN 0 DC 0.9 AC 1 SIN(0.9 0.1 1MEG 0 0)

* Circuit
XQ3 N5 N3 N6 0 sky130_fd_pr__npn_05v5_W1p00L1p00
R1 N1 N4 10k
XQ4 N3 N0 GND 0 sky130_fd_pr__npn_05v5_W1p00L1p00
XQ1 N2 N4 GND 0 sky130_fd_pr__npn_05v5_W1p00L1p00
R3 VDD N5 10k
C2 N1 GND 1p
C1 N4 IN 1p
R5 VDD N3 10k
R2 N0 N1 10k
C4_OUT N2 OUT 1p
XQ2 VDD N5 N1 0 sky130_fd_pr__npn_05v5_W1p00L1p00
C4 N3 GND 1p
C3 N5 GND 1p
R4 N6 GND 10k
L1 VDD N2 10n

.control
set filetype=ascii

op
let vdd_current = abs(i(VVDD))
let power_dc = vdd_current * 1.8
print power_dc

ac dec 100 1k 100g
let vout_mag = vm(OUT)
let gain_db = db(vout_mag)

meas ac max_gain_db MAX gain_db
meas ac bw_3db WHEN gain_db='max_gain_db-3' CROSS=1

print max_gain_db bw_3db

quit
.endc

.end
