* Testcase 000105 — Full Analysis (sky130 tt corner)
* SKY130 model header — replaces the ideal level-1 .model cards
* Ships with the demo; the paths point at the local sky130 PDK checkout.
* NOTE: libs.tech/ngspice/all.spice sets ".option scale=1.0u", so every
* instance L/W below is written in microns WITHOUT a "u" suffix.
.param mc_mm_switch=0
.param mc_pr_switch=0
.include /home/idies/workspace/Temporary/xyu1/scratch/skywater-pdk-libs-sky130_fd_pr/models/corners/tt.spice
.include /home/idies/workspace/Temporary/xyu1/scratch/skywater-pdk-libs-sky130_fd_pr/models/r+c/res_typical__cap_typical.spice
.include /home/idies/workspace/Temporary/xyu1/scratch/skywater-pdk-libs-sky130_fd_pr/models/r+c/res_typical__cap_typical__lin.spice
.include /home/idies/workspace/Temporary/xyu1/scratch/skywater-pdk-libs-sky130_fd_pr/models/corners/tt/specialized_cells.spice
.model DIDEAL D   is=1e-14 n=1
.options reltol=1e-3 itl1=500 itl2=100

* Sources
VLABEL_NET_0 LABEL_NET_0 0 DC 0.9 AC 0.5

* Circuit
L1 N0 N9 10n
L2 N1 N5 10n
L3 N5 N14 10n
L4 N6 N10 10n
R1 N15 GND 10k
L5 N3 N4 10n
R2 N12 GND 10k
L6 N2 N7 10n
R3 N8 GND 10k
R4 N11 GND 10k
C1 N9 N10 1p
R5 N10 N13 10k
C2 N4 LABEL_NET_0 1p
C3 N2 GND 1p
C4 N5 GND 1p
C5 N7 N14 1p
R6 N4 N16 10k
C6 N0 N15 1p
C7 N1 N12 1p
C8 N3 N11 1p
C9 N6 N8 1p
XM1 N5 N13 GND GND sky130_fd_pr__nfet_01v8 l=0.5 w=5
XM2 GND N16 N9 GND sky130_fd_pr__nfet_01v8 l=0.5 w=5

.control
set filetype=ascii

op
let vdd_current = abs(i(VVDD))
let power_dc = vdd_current * 1.8
print power_dc

ac dec 100 1k 100g
let vout_mag = vm(N15)
let gain_db = db(vout_mag)

meas ac max_gain_db MAX gain_db
meas ac bw_3db WHEN gain_db='max_gain_db-3' CROSS=1

print max_gain_db bw_3db

quit
.endc

.end
