* Testcase 000490 — Full Analysis (sky130 tt corner)
* SKY130 model header — replaces the ideal level-1 .model cards
* Ships with the demo; the paths point at the local sky130 PDK checkout.
* NOTE: libs.tech/ngspice/all.spice sets ".option scale=1.0u", so every
* instance L/W below is written in microns WITHOUT a "u" suffix.
.param mc_mm_switch=0
.param mc_pr_switch=0
.include /home/idies/workspace/Temporary/xyu1/scratch/skywater-pdk-libs-sky130_fd_pr/models/corners/tt.spice
.include /home/idies/workspace/Temporary/xyu1/scratch/skywater-pdk-libs-sky130_fd_pr/models/r+c/res_typical__cap_typical.spice
.include /home/idies/workspace/Temporary/xyu1/scratch/skywater-pdk-libs-sky130_fd_pr/models/r+c/res_typical__cap_typical__lin.spice
.include /home/idies/workspace/Temporary/xyu1/scratch/skywater-pdk-libs-sky130_fd_pr/models/corners/tt/specialized_cells.spice
.model DIDEAL D   is=1e-14 n=1
.options reltol=1e-3 itl1=500 itl2=100

* Sources
VVBIAS VBIAS 0 0.75

* Circuit
R1 VEE N10 10k
R2 VEE N15 10k
R3 N0 VCC 10k
R4 N2 VCC 10k
R5 VEE N6 10k
XQ3 N13 VBIAS N15 0 sky130_fd_pr__npn_05v5_W1p00L1p00
XQ4 N16 VBIAS N10 0 sky130_fd_pr__npn_05v5_W1p00L1p00
XQ1 N0 VBIAS VEE 0 sky130_fd_pr__npn_05v5_W1p00L1p00
XQ2 N16 VBIAS N10 0 sky130_fd_pr__npn_05v5_W1p00L1p00
XQ5 N7 VBIAS N6 0 sky130_fd_pr__npn_05v5_W1p00L1p00
XQ6 N4 CK_BAR N7 0 sky130_fd_pr__npn_05v5_W1p00L1p00
XQ7 N2 DBAR N4 0 sky130_fd_pr__npn_05v5_W1p00L1p00
XQ8 N0 D N4 0 sky130_fd_pr__npn_05v5_W1p00L1p00
XQ9 N12 N12 N13 0 sky130_fd_pr__npn_05v5_W1p00L1p00
XQ10 N2 Q_BAR N8 0 sky130_fd_pr__npn_05v5_W1p00L1p00
XQ11 N11 N11 N16 0 sky130_fd_pr__npn_05v5_W1p00L1p00
XQ12 Q Q N11 0 sky130_fd_pr__npn_05v5_W1p00L1p00
XQ13 N0 Q N8 0 sky130_fd_pr__npn_05v5_W1p00L1p00
XQ14 Q_BAR Q_BAR N12 0 sky130_fd_pr__npn_05v5_W1p00L1p00
XQ15 N8 CK N7 0 sky130_fd_pr__npn_05v5_W1p00L1p00

.control
set filetype=ascii

op
let power_dc = abs(i(VVBIAS)) * 1.8
print power_dc
let dc_voltage = v(N0)
print dc_voltage

quit
.endc

.end
