* Testcase 001105 — Full Analysis (sky130 tt corner)
* SKY130 model header — replaces the ideal level-1 .model cards
* Ships with the demo; the paths point at the local sky130 PDK checkout.
* NOTE: libs.tech/ngspice/all.spice sets ".option scale=1.0u", so every
* instance L/W below is written in microns WITHOUT a "u" suffix.
.param mc_mm_switch=0
.param mc_pr_switch=0
.include /home/idies/workspace/Temporary/xyu1/scratch/skywater-pdk-libs-sky130_fd_pr/models/corners/tt.spice
.include /home/idies/workspace/Temporary/xyu1/scratch/skywater-pdk-libs-sky130_fd_pr/models/r+c/res_typical__cap_typical.spice
.include /home/idies/workspace/Temporary/xyu1/scratch/skywater-pdk-libs-sky130_fd_pr/models/r+c/res_typical__cap_typical__lin.spice
.include /home/idies/workspace/Temporary/xyu1/scratch/skywater-pdk-libs-sky130_fd_pr/models/corners/tt/specialized_cells.spice
.model DIDEAL D   is=1e-14 n=1
.options reltol=1e-3 itl1=500 itl2=100

* Sources
VVBP VBP 0 DC 0.75 AC 1

* Circuit
IB1 GND GND 1u
IB3 N0 GND 1u
IB5 N4 N8 1u
IB4 N1 GND 1u
IB6 N8 GND 1u
IB2 N7 GND 1u
R5 VLP N7 10k
C1 N0 VBP 1p
R1 N0 VHP 10k
C2 N1 VLP 1p
R9 N4 V2 10k
R10 VBP N4 10k
R3 V1 GND 10k
R2 N1 VBP 10k
R6 VHP N7 10k
R4 VBP GND 10k
R7 VHP N8 10k
R8 VLP N8 10k

.control
set filetype=ascii

op
let power_dc = abs(i(VVBP)) * 1.8
print power_dc

ac dec 100 1 100g

let vmag = vm(VLP)
let vdb = db(vmag)

* Gain at key frequencies
meas ac gain_1khz_db FIND vdb AT=1e3
meas ac gain_1mhz_db FIND vdb AT=1e6
meas ac gain_1ghz_db FIND vdb AT=1e9

* Try to find 3dB bandwidth
meas ac max_gain MAX vdb
meas ac bw_3db_hz WHEN vdb='max_gain-3' CROSS=1

print gain_1khz_db gain_1mhz_db gain_1ghz_db bw_3db_hz

quit
.endc

.end
