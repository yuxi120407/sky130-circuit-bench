* Testcase 000680 — Full Analysis (sky130 tt corner)
* SKY130 model header — replaces the ideal level-1 .model cards
* Ships with the demo; the paths point at the local sky130 PDK checkout.
* NOTE: libs.tech/ngspice/all.spice sets ".option scale=1.0u", so every
* instance L/W below is written in microns WITHOUT a "u" suffix.
.param mc_mm_switch=0
.param mc_pr_switch=0
.include /home/idies/workspace/Temporary/xyu1/scratch/skywater-pdk-libs-sky130_fd_pr/models/corners/tt.spice
.include /home/idies/workspace/Temporary/xyu1/scratch/skywater-pdk-libs-sky130_fd_pr/models/r+c/res_typical__cap_typical.spice
.include /home/idies/workspace/Temporary/xyu1/scratch/skywater-pdk-libs-sky130_fd_pr/models/r+c/res_typical__cap_typical__lin.spice
.include /home/idies/workspace/Temporary/xyu1/scratch/skywater-pdk-libs-sky130_fd_pr/models/corners/tt/specialized_cells.spice
.model DIDEAL D   is=1e-14 n=1
.options reltol=1e-3 itl1=500 itl2=100

* Sources

* Circuit
I1 N15 GND 1u
I2 N1 GND 1u
XQ1 N4 N11 N7 0 sky130_fd_pr__npn_05v5_W1p00L1p00
R1 ERROR VCC 10k
R2 ERROR VCC 10k
C1 ERROR VCC 1p
C2 ERROR VCC 1p
R3 N15 IFRA 10k
XQ2 N14 IFRA N8 0 sky130_fd_pr__npn_05v5_W1p00L1p00
R4 IFRA N15 10k
XQ3 N9 N2 N7 0 sky130_fd_pr__npn_05v5_W1p00L1p00
XQ4 N13 IFRA N14 0 sky130_fd_pr__npn_05v5_W1p00L1p00
XQ5 ERROR N3 N9 0 sky130_fd_pr__npn_05v5_W1p00L1p00
R5 N1 N7 10k
R6 N1 N7 10k
XQ6 ERROR N3 N4 0 sky130_fd_pr__npn_05v5_W1p00L1p00
XQ7 ERROR N7 N9 0 sky130_fd_pr__npn_05v5_W1p00L1p00
XQ8 ERROR N0 N8 0 sky130_fd_pr__npn_05v5_W1p00L1p00
XQ9 ERROR N14 N13 0 sky130_fd_pr__npn_05v5_W1p00L1p00
XQ10 ERROR N14 N8 0 sky130_fd_pr__npn_05v5_W1p00L1p00
XQ11 ERROR N0 N13 0 sky130_fd_pr__npn_05v5_W1p00L1p00
XQ12 ERROR N7 N4 0 sky130_fd_pr__npn_05v5_W1p00L1p00

.control
set filetype=ascii

op
let power_dc = 0
print power_dc
let dc_voltage = v(ERROR)
print dc_voltage

quit
.endc

.end
