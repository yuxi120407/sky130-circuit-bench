* Testcase 000915 — Full Analysis (sky130 tt corner)
* SKY130 model header — replaces the ideal level-1 .model cards
* Ships with the demo; the paths point at the local sky130 PDK checkout.
* NOTE: libs.tech/ngspice/all.spice sets ".option scale=1.0u", so every
* instance L/W below is written in microns WITHOUT a "u" suffix.
.param mc_mm_switch=0
.param mc_pr_switch=0
.include /home/idies/workspace/Temporary/xyu1/scratch/skywater-pdk-libs-sky130_fd_pr/models/corners/tt.spice
.include /home/idies/workspace/Temporary/xyu1/scratch/skywater-pdk-libs-sky130_fd_pr/models/r+c/res_typical__cap_typical.spice
.include /home/idies/workspace/Temporary/xyu1/scratch/skywater-pdk-libs-sky130_fd_pr/models/r+c/res_typical__cap_typical__lin.spice
.include /home/idies/workspace/Temporary/xyu1/scratch/skywater-pdk-libs-sky130_fd_pr/models/corners/tt/specialized_cells.spice
.model DIDEAL D   is=1e-14 n=1
.options reltol=1e-3 itl1=500 itl2=100

* Sources
VVDD VDD 0 1.8
VVBIAS_EN_BAR VBIAS_EN_BAR 0 DC 0.54 AC 1
VVBIAS_EN VBIAS_EN 0 0.54

* Circuit
XM2D N0 VBIAS_EN_BAR GND GND sky130_fd_pr__nfet_01v8 l=0.5 w=5
XM5 N1 VBIAS_EN GND GND sky130_fd_pr__nfet_01v8 l=0.5 w=5
XM8 CM I_MINUS N0 GND sky130_fd_pr__nfet_01v8 l=0.5 w=5
XM1D CM I_PLUS N0 GND sky130_fd_pr__nfet_01v8 l=0.5 w=5
XM2 N1 VBIAS_EN GND GND sky130_fd_pr__nfet_01v8 l=0.5 w=5
XM6 N0 VBIAS_EN_BAR GND GND sky130_fd_pr__nfet_01v8 l=0.5 w=5
XM7 O_PLUS I_MINUS N1 GND sky130_fd_pr__nfet_01v8 l=0.5 w=5
XM3 O_MINUS CMFB N4 VDD sky130_fd_pr__pfet_01v8 l=0.5 w=5
XM9 O_PLUS CMFB N12 VDD sky130_fd_pr__pfet_01v8 l=0.5 w=5
XM1 O_MINUS I_PLUS N1 GND sky130_fd_pr__nfet_01v8 l=0.5 w=5
XM4 N4 VDD_EN_BAR VDD VDD sky130_fd_pr__pfet_01v8 l=0.5 w=5
XM12 N12 VDD_EN_BAR VDD VDD sky130_fd_pr__pfet_01v8 l=0.5 w=5

.control
set filetype=ascii

op
let power_dc = abs(i(VVDD)) * 1.8
print power_dc

ac dec 100 1 10g
let gain_CM = db(vm(CM))
let gain_CMFB = db(vm(CMFB))
let gain_O_PLUS = db(vm(O_PLUS))
let gain_N4 = db(vm(N4))
let gain_I_PLUS = db(vm(I_PLUS))
meas ac max_gain_CM MAX gain_CM
meas ac max_gain_CMFB MAX gain_CMFB
meas ac max_gain_O_PLUS MAX gain_O_PLUS
meas ac max_gain_N4 MAX gain_N4
meas ac max_gain_I_PLUS MAX gain_I_PLUS

* Use first probe node for standard metrics
let gain_db = db(vm(CM))
meas ac dc_gain_db FIND gain_db AT=1
meas ac ugbw WHEN gain_db=0 CROSS=1
let vout_dc = v(CM)

print dc_gain_db ugbw vout_dc gain_CM gain_CMFB gain_O_PLUS gain_N4 gain_I_PLUS

quit
.endc

.end
