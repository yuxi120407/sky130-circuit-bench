* Testcase 000329 — Full Analysis (sky130 tt corner)
* SKY130 model header — replaces the ideal level-1 .model cards
* Ships with the demo; the paths point at the local sky130 PDK checkout.
* NOTE: libs.tech/ngspice/all.spice sets ".option scale=1.0u", so every
* instance L/W below is written in microns WITHOUT a "u" suffix.
.param mc_mm_switch=0
.param mc_pr_switch=0
.include /home/idies/workspace/Temporary/xyu1/scratch/skywater-pdk-libs-sky130_fd_pr/models/corners/tt.spice
.include /home/idies/workspace/Temporary/xyu1/scratch/skywater-pdk-libs-sky130_fd_pr/models/r+c/res_typical__cap_typical.spice
.include /home/idies/workspace/Temporary/xyu1/scratch/skywater-pdk-libs-sky130_fd_pr/models/r+c/res_typical__cap_typical__lin.spice
.include /home/idies/workspace/Temporary/xyu1/scratch/skywater-pdk-libs-sky130_fd_pr/models/corners/tt/specialized_cells.spice
.model DIDEAL D   is=1e-14 n=1
.options reltol=1e-3 itl1=500 itl2=100

* Sources
VVDD VDD 0 1.8
VLABEL_NET_0 LABEL_NET_0 0 DC 0.9 AC 0.5
VLABEL_NET_1 LABEL_NET_1 0 DC 0.9 AC -0.5
VLABEL_NET_2 LABEL_NET_2 0 0.9
VLABEL_NET_3 LABEL_NET_3 0 0.9
VLABEL_NET_4 LABEL_NET_4 0 0.9
VLABEL_NET_5 LABEL_NET_5 0 0.9

* Circuit
XQ1 N0 N3 N1 0 sky130_fd_pr__npn_05v5_W1p00L1p00
XM1 N2 LABEL_NET_0 N4 GND sky130_fd_pr__nfet_01v8 l=0.5 w=5
XQ2 N5 LABEL_NET_1 N1 0 sky130_fd_pr__npn_05v5_W1p00L1p00
XM2 N1 LABEL_NET_2 N6 GND sky130_fd_pr__nfet_01v8 l=0.5 w=5
XQ3 N5 N3 N2 0 sky130_fd_pr__npn_05v5_W1p00L1p00
XQ4 N0 LABEL_NET_3 N2 0 sky130_fd_pr__npn_05v5_W1p00L1p00
R1 VDD LABEL_NET_4 10k
R2 VDD LABEL_NET_5 10k
R3 N6 GND 10k
R4 N4 GND 10k
C1 VDD N5 1p
C2 VDD N0 1p

.control
set filetype=ascii

op
let vdd_current = abs(i(VVDD))
let power_dc = vdd_current * 1.8
print power_dc

ac dec 100 1 10g
let vout_mag = vm(N6)
let gain_db = db(vout_mag)
let dc_gain_db = gain_db[0]
print dc_gain_db

if dc_gain_db > 0
    meas ac ugbw WHEN gain_db=0 CROSS=1
end

quit
.endc

.end
