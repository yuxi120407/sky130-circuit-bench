* Testcase 000827 — Full Analysis (sky130 tt corner)
* SKY130 model header — replaces the ideal level-1 .model cards
* Ships with the demo; the paths point at the local sky130 PDK checkout.
* NOTE: libs.tech/ngspice/all.spice sets ".option scale=1.0u", so every
* instance L/W below is written in microns WITHOUT a "u" suffix.
.param mc_mm_switch=0
.param mc_pr_switch=0
.include /home/idies/workspace/Temporary/xyu1/scratch/skywater-pdk-libs-sky130_fd_pr/models/corners/tt.spice
.include /home/idies/workspace/Temporary/xyu1/scratch/skywater-pdk-libs-sky130_fd_pr/models/r+c/res_typical__cap_typical.spice
.include /home/idies/workspace/Temporary/xyu1/scratch/skywater-pdk-libs-sky130_fd_pr/models/r+c/res_typical__cap_typical__lin.spice
.include /home/idies/workspace/Temporary/xyu1/scratch/skywater-pdk-libs-sky130_fd_pr/models/corners/tt/specialized_cells.spice
.model DIDEAL D   is=1e-14 n=1
.options reltol=1e-3 itl1=500 itl2=100

* Sources
VVDD VDD 0 1.8

* Circuit
I1 GND N6 1u
XM1 N4 N7 GND GND sky130_fd_pr__nfet_01v8 l=0.5 w=5
I2 GND N4 1u
XM2 N6 N0 GND GND sky130_fd_pr__nfet_01v8 l=0.5 w=5
XM3 IF_OUT_P GND N4 GND sky130_fd_pr__nfet_01v8 l=0.5 w=5
XM4 IF_OUT_N GND N6 GND sky130_fd_pr__nfet_01v8 l=0.5 w=5
XM5 IF_OUT_N RF_LO N4 GND sky130_fd_pr__nfet_01v8 l=0.5 w=5
XM6 IF_OUT_P RF_LO N6 GND sky130_fd_pr__nfet_01v8 l=0.5 w=5
R1 N7 BIAS 10k
R2 VDD IF_OUT_P 10k
C1 VDD IF_OUT_N 1p
C2 N7 RF_IN_P 1p
C3 VDD IF_OUT_P 1p
R3 N0 BIAS 10k
R4 VDD IF_OUT_N 10k
C4 N0 RF_IN_N 1p

.control
set filetype=ascii

op
let vdd_current = abs(i(VVDD))
let power_dc = vdd_current * 1.8
print power_dc

print all

let vout_dc = v(N6)
print vout_dc
let vout_dc = v(N6)
print vout_dc
quit
.endc

.end
