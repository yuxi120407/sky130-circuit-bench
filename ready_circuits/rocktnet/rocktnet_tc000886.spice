* Testcase 000886 — Full Analysis (sky130 tt corner)
* SKY130 model header — replaces the ideal level-1 .model cards
* Ships with the demo; the paths point at the local sky130 PDK checkout.
* NOTE: libs.tech/ngspice/all.spice sets ".option scale=1.0u", so every
* instance L/W below is written in microns WITHOUT a "u" suffix.
.param mc_mm_switch=0
.param mc_pr_switch=0
.include /home/idies/workspace/Temporary/xyu1/scratch/skywater-pdk-libs-sky130_fd_pr/models/corners/tt.spice
.include /home/idies/workspace/Temporary/xyu1/scratch/skywater-pdk-libs-sky130_fd_pr/models/r+c/res_typical__cap_typical.spice
.include /home/idies/workspace/Temporary/xyu1/scratch/skywater-pdk-libs-sky130_fd_pr/models/r+c/res_typical__cap_typical__lin.spice
.include /home/idies/workspace/Temporary/xyu1/scratch/skywater-pdk-libs-sky130_fd_pr/models/corners/tt/specialized_cells.spice
.model DIDEAL D   is=1e-14 n=1
.options reltol=1e-3 itl1=500 itl2=100

* Sources

* Circuit
I1 VCC_BIAS N8 1u
I2 VCC_BIAS N0 1u
XQ3 N0 N8 N6 0 sky130_fd_pr__npn_05v5_W1p00L1p00
XQ7 N1 N5 N0 sky130_fd_pr__pnp_05v5_W3p40L3p40
XQ2 N3 N7 GND 0 sky130_fd_pr__npn_05v5_W1p00L1p00
XQ8 N6 N1 GND 0 sky130_fd_pr__npn_05v5_W1p00L1p00
XQ4 N5 N5 GND 0 sky130_fd_pr__npn_05v5_W1p00L1p00
XQ9 N8 N1 GND 0 sky130_fd_pr__npn_05v5_W1p00L1p00
XQ1 N8 N8 N5 0 sky130_fd_pr__npn_05v5_W1p00L1p00
C1 N3 PA_OUT 1p
C2 N7 RF_IN 1p
L1 N6 N7 10n
L2 N3 VCC_PA 10n

.control
set filetype=ascii

op
let power_dc = 0
print power_dc
let dc_voltage = v(N3)
print dc_voltage

quit
.endc

.end
