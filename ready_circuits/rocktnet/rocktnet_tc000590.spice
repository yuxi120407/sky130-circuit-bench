* Testcase 000590 — Full Analysis (sky130 tt corner)
* SKY130 model header — replaces the ideal level-1 .model cards
* Ships with the demo; the paths point at the local sky130 PDK checkout.
* NOTE: libs.tech/ngspice/all.spice sets ".option scale=1.0u", so every
* instance L/W below is written in microns WITHOUT a "u" suffix.
.param mc_mm_switch=0
.param mc_pr_switch=0
.include /home/idies/workspace/Temporary/xyu1/scratch/skywater-pdk-libs-sky130_fd_pr/models/corners/tt.spice
.include /home/idies/workspace/Temporary/xyu1/scratch/skywater-pdk-libs-sky130_fd_pr/models/r+c/res_typical__cap_typical.spice
.include /home/idies/workspace/Temporary/xyu1/scratch/skywater-pdk-libs-sky130_fd_pr/models/r+c/res_typical__cap_typical__lin.spice
.include /home/idies/workspace/Temporary/xyu1/scratch/skywater-pdk-libs-sky130_fd_pr/models/corners/tt/specialized_cells.spice
.model DIDEAL D   is=1e-14 n=1
.options reltol=1e-3 itl1=500 itl2=100

* Sources
VVINP VINP 0 DC 0.9 AC 1 SIN(0.9 0.1 1MEG 0 0)
VVINM VINM 0 DC 0.9 AC 1 SIN(0.9 0.1 1MEG 0 0)

* Circuit
C1 N8 N9 1p
C2 N8 N14 1p
C3 N15 GND 1p
C4 N1 N2 1p
C5 N11 GND 1p
C6 N6 N7 1p
R1 VOUTP N6 10k
R2 N2 VOUTM 10k
C7 VOUTP N10 1p
C8 N10 N13 1p

.control
set filetype=ascii

op
let power_dc = abs(i(VVINP)) * 1.8
print power_dc

ac dec 100 1 10g
let vout_mag = vm(N15)
let gain_db = db(vout_mag)

meas ac max_gain_db MAX gain_db
meas ac bw_3db WHEN gain_db='max_gain_db-3' CROSS=1

print max_gain_db bw_3db

quit
.endc

.end
