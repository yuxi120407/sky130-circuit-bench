* Testcase 000940 — Full Analysis (sky130 tt corner)
* SKY130 model header — replaces the ideal level-1 .model cards
* Ships with the demo; the paths point at the local sky130 PDK checkout.
* NOTE: libs.tech/ngspice/all.spice sets ".option scale=1.0u", so every
* instance L/W below is written in microns WITHOUT a "u" suffix.
.param mc_mm_switch=0
.param mc_pr_switch=0
.include /home/idies/workspace/Temporary/xyu1/scratch/skywater-pdk-libs-sky130_fd_pr/models/corners/tt.spice
.include /home/idies/workspace/Temporary/xyu1/scratch/skywater-pdk-libs-sky130_fd_pr/models/r+c/res_typical__cap_typical.spice
.include /home/idies/workspace/Temporary/xyu1/scratch/skywater-pdk-libs-sky130_fd_pr/models/r+c/res_typical__cap_typical__lin.spice
.include /home/idies/workspace/Temporary/xyu1/scratch/skywater-pdk-libs-sky130_fd_pr/models/corners/tt/specialized_cells.spice
.model DIDEAL D   is=1e-14 n=1
.options reltol=1e-3 itl1=500 itl2=100

* Sources
VVDD VDD 0 1.8
VVIN_POS VIN_POS 0 DC 0.9 AC 1 SIN(0.9 0.1 1MEG 0 0)
VVIN_NEG VIN_NEG 0 DC 0.9 AC 1 SIN(0.9 0.1 1MEG 0 0)
VVINT_POS VINT_POS 0 DC 0.9 AC 1 SIN(0.9 0.1 1MEG 0 0)
VIN_POS IN_POS 0 DC 0.9 AC 1 SIN(0.9 0.1 1MEG 0 0)
VIN_NEG IN_NEG 0 DC 0.9 AC 1 SIN(0.9 0.1 1MEG 0 0)
VVINT_NEG VINT_NEG 0 DC 0.9 AC 1 SIN(0.9 0.1 1MEG 0 0)

* Circuit
I1 VDD VIN_POS 2u
I2 VDD VIN_NEG 10u
XQL GND GND VIN_POS sky130_fd_pr__pnp_05v5_W3p40L3p40
XQR GND GND VIN_NEG sky130_fd_pr__pnp_05v5_W3p40L3p40
C3 VIN_POS VINT_POS 1p
C2 VIN_POS IN_POS 1p
C1 VIN_NEG IN_NEG 1p
C4 GND VINT_NEG 1p

.control
set filetype=ascii

op
let vdd_current = abs(i(VVDD))
let power_dc = vdd_current * 1.8
print power_dc

ac dec 100 1 10g
let vout_mag = vm(VINT_NEG)
let gain_db = db(vout_mag)

meas ac max_gain_db MAX gain_db
meas ac bw_3db WHEN gain_db='max_gain_db-3' CROSS=1

print max_gain_db bw_3db

quit
.endc

.end
