* Testcase 000669 — Full Analysis (sky130 tt corner)
* SKY130 model header — replaces the ideal level-1 .model cards
* Ships with the demo; the paths point at the local sky130 PDK checkout.
* NOTE: libs.tech/ngspice/all.spice sets ".option scale=1.0u", so every
* instance L/W below is written in microns WITHOUT a "u" suffix.
.param mc_mm_switch=0
.param mc_pr_switch=0
.include /home/idies/workspace/Temporary/xyu1/scratch/skywater-pdk-libs-sky130_fd_pr/models/corners/tt.spice
.include /home/idies/workspace/Temporary/xyu1/scratch/skywater-pdk-libs-sky130_fd_pr/models/r+c/res_typical__cap_typical.spice
.include /home/idies/workspace/Temporary/xyu1/scratch/skywater-pdk-libs-sky130_fd_pr/models/r+c/res_typical__cap_typical__lin.spice
.include /home/idies/workspace/Temporary/xyu1/scratch/skywater-pdk-libs-sky130_fd_pr/models/corners/tt/specialized_cells.spice
.model DIDEAL D   is=1e-14 n=1
.options reltol=1e-3 itl1=500 itl2=100

* Sources
VVDD VDD 0 1.8
VINI_CHGB INI_CHGB 0 DC 0.9 AC 1 SIN(0.9 0.1 1MEG 0 0)
VINI_CHG INI_CHG 0 DC 0.9 AC 1 SIN(0.9 0.1 1MEG 0 0)

* Circuit
XM8 N4 INI_CHGB VDD VDD sky130_fd_pr__pfet_01v8 l=0.5 w=5
XM7 N6 ENB VDD VDD sky130_fd_pr__pfet_01v8 l=0.5 w=5
XM6 N0 CAS_BIAS GND GND sky130_fd_pr__nfet_01v8 l=0.5 w=5
XM5 BITLINE INI_CHG GND GND sky130_fd_pr__nfet_01v8 l=0.5 w=5
R1 VDD A 10k
XM2 B CASREF N0 GND sky130_fd_pr__nfet_01v8 l=0.5 w=5
XM1 A BITLINE N0 GND sky130_fd_pr__nfet_01v8 l=0.5 w=5
RSENSE SAIN N6 10k
R3 VDD B 10k
XM4 BITLINE A N4 VDD sky130_fd_pr__pfet_01v8 l=0.5 w=5
XM3 SAIN A BITLINE GND sky130_fd_pr__nfet_01v8 l=0.5 w=5

.control
set filetype=ascii

op
let power_dc = abs(i(VVDD)) * 1.8
print power_dc

ac dec 100 1 10g
let vout_mag = vm(BITLINE)
let gain_db = db(vout_mag)
let dc_gain_db = gain_db[0]
print dc_gain_db

if dc_gain_db > 0
    meas ac ugbw WHEN gain_db=0 CROSS=1
    print ugbw
end

quit
.endc

.end
