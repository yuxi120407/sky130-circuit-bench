* Testcase 000711 — Full Analysis (sky130 tt corner)
* SKY130 model header — replaces the ideal level-1 .model cards
* Ships with the demo; the paths point at the local sky130 PDK checkout.
* NOTE: libs.tech/ngspice/all.spice sets ".option scale=1.0u", so every
* instance L/W below is written in microns WITHOUT a "u" suffix.
.param mc_mm_switch=0
.param mc_pr_switch=0
.include /home/idies/workspace/Temporary/xyu1/scratch/skywater-pdk-libs-sky130_fd_pr/models/corners/tt.spice
.include /home/idies/workspace/Temporary/xyu1/scratch/skywater-pdk-libs-sky130_fd_pr/models/r+c/res_typical__cap_typical.spice
.include /home/idies/workspace/Temporary/xyu1/scratch/skywater-pdk-libs-sky130_fd_pr/models/r+c/res_typical__cap_typical__lin.spice
.include /home/idies/workspace/Temporary/xyu1/scratch/skywater-pdk-libs-sky130_fd_pr/models/corners/tt/specialized_cells.spice
.model DIDEAL D   is=1e-14 n=1
.options reltol=1e-3 itl1=500 itl2=100

* Sources
VVDD VDD 0 1.8
VIN IN 0 DC 0.9 AC 1 SIN(0.9 0.1 1MEG 0 0)

* Circuit
I1 N5 GND 1u
XM1 N0 IN N5 GND sky130_fd_pr__nfet_01v8 l=0.5 w=5
I2 N3 GND 1u
I3 OUT GND 1u
XM2 N2 N3 N5 GND sky130_fd_pr__nfet_01v8 l=0.5 w=5
XM5 VDD N1 N3 GND sky130_fd_pr__nfet_01v8 l=0.5 w=5
XM5_PRIME VDD N1 OUT GND sky130_fd_pr__nfet_01v8 l=0.5 w=5
XM3 N0 N0 VDD VDD sky130_fd_pr__pfet_01v8 l=0.5 w=5
XM4 N2 N0 VDD VDD sky130_fd_pr__pfet_01v8 l=0.5 w=5
XM6 N1 RESET_BAR VDD VDD sky130_fd_pr__pfet_01v8 l=0.5 w=5
CHOLD VDD N1 1p
D1 N1 N2 DIDEAL

.control
set filetype=ascii

op
let vdd_current = abs(i(VVDD))
let power_dc = vdd_current * 1.8
print power_dc

ac dec 100 1 10g
let vout_mag = vm(OUT)
let gain_db = db(vout_mag)
let dc_gain_db = gain_db[0]
print dc_gain_db

if dc_gain_db > 0
    meas ac ugbw WHEN gain_db=0 CROSS=1
end

quit
.endc

.end
