* Testcase 000296 — Full Analysis (sky130 tt corner)
* SKY130 model header — replaces the ideal level-1 .model cards
* Ships with the demo; the paths point at the local sky130 PDK checkout.
* NOTE: libs.tech/ngspice/all.spice sets ".option scale=1.0u", so every
* instance L/W below is written in microns WITHOUT a "u" suffix.
.param mc_mm_switch=0
.param mc_pr_switch=0
.include /home/idies/workspace/Temporary/xyu1/scratch/skywater-pdk-libs-sky130_fd_pr/models/corners/tt.spice
.include /home/idies/workspace/Temporary/xyu1/scratch/skywater-pdk-libs-sky130_fd_pr/models/r+c/res_typical__cap_typical.spice
.include /home/idies/workspace/Temporary/xyu1/scratch/skywater-pdk-libs-sky130_fd_pr/models/r+c/res_typical__cap_typical__lin.spice
.include /home/idies/workspace/Temporary/xyu1/scratch/skywater-pdk-libs-sky130_fd_pr/models/corners/tt/specialized_cells.spice
.model DIDEAL D   is=1e-14 n=1
.options reltol=1e-3 itl1=500 itl2=100

* Sources
VVDD VDD 0 1.8
VVIN VIN 0 DC 0.9 AC 1 SIN(0.9 0.1 1MEG 0 0)
VVB1 VB1 0 0.54
VVB2 VB2 0 0.75

* Circuit
LP N0 N1 10n
L2 VDD N4 10n
LS N6 GND 10n
XM3 N2 N3 N0 GND sky130_fd_pr__nfet_01v8 l=0.5 w=5
L4 VDD N5 10n
XM4 N4 VLO N2 GND sky130_fd_pr__nfet_01v8 l=0.5 w=5
XM1 N7 VIN N6 GND sky130_fd_pr__nfet_01v8 l=0.5 w=5
XM5 N5 N2 N2 GND sky130_fd_pr__nfet_01v8 l=0.5 w=5
XM2 N1 VB1 N7 GND sky130_fd_pr__nfet_01v8 l=0.5 w=5
R1 N3 VB2 10k
CP N0 N1 1p
CC N1 N3 1p
CB1 N0 GND 1p

.control
set filetype=ascii

op
let vdd_current = abs(i(VVDD))
let power_dc = vdd_current * 1.8
print power_dc

ac dec 100 1k 100g
let vout_mag = vm(N0)
let gain_db = db(vout_mag)

meas ac max_gain_db MAX gain_db
meas ac bw_3db WHEN gain_db='max_gain_db-3' CROSS=1

print max_gain_db bw_3db

quit
.endc

.end
