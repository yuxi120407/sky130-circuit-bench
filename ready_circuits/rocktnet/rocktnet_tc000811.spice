* Testcase 000811 — Full Analysis (sky130 tt corner)
* SKY130 model header — replaces the ideal level-1 .model cards
* Ships with the demo; the paths point at the local sky130 PDK checkout.
* NOTE: libs.tech/ngspice/all.spice sets ".option scale=1.0u", so every
* instance L/W below is written in microns WITHOUT a "u" suffix.
.param mc_mm_switch=0
.param mc_pr_switch=0
.include /home/idies/workspace/Temporary/xyu1/scratch/skywater-pdk-libs-sky130_fd_pr/models/corners/tt.spice
.include /home/idies/workspace/Temporary/xyu1/scratch/skywater-pdk-libs-sky130_fd_pr/models/r+c/res_typical__cap_typical.spice
.include /home/idies/workspace/Temporary/xyu1/scratch/skywater-pdk-libs-sky130_fd_pr/models/r+c/res_typical__cap_typical__lin.spice
.include /home/idies/workspace/Temporary/xyu1/scratch/skywater-pdk-libs-sky130_fd_pr/models/corners/tt/specialized_cells.spice
.model DIDEAL D   is=1e-14 n=1
.options reltol=1e-3 itl1=500 itl2=100

* Sources
VVDD VDD 0 1.8
VVSS VSS 0 0
VIN_PLUS IN_PLUS 0 DC 0.9 AC 1 SIN(0.9 0.1 1MEG 0 0)
VLABEL_NET_3 LABEL_NET_3 0 0.9
VLABEL_NET_4 LABEL_NET_4 0 0.9
VIN_MINUS IN_MINUS 0 DC 0.9 AC 1 SIN(0.9 0.1 1MEG 0 0)

* Circuit
XM1 N16 N0 N1 GND sky130_fd_pr__nfet_01v8 l=0.5 w=5
XM2 N1 N18 VSS VDD sky130_fd_pr__pfet_01v8 l=0.5 w=5
XM3 N4 N14 VSS VDD sky130_fd_pr__pfet_01v8 l=0.5 w=5
XM4 VSS N9 VSS VDD sky130_fd_pr__pfet_01v8 l=0.5 w=5
XM5 N20 N0 N20 GND sky130_fd_pr__nfet_01v8 l=0.5 w=5
XM6 N6 N23 VSS VDD sky130_fd_pr__pfet_01v8 l=0.5 w=5
XM7 N22 N19 N1 GND sky130_fd_pr__nfet_01v8 l=0.5 w=5
XM8 N10 N14 VSS VDD sky130_fd_pr__pfet_01v8 l=0.5 w=5
XM9 OUT N17 N4 VDD sky130_fd_pr__pfet_01v8 l=0.5 w=5
XM10 N19 N1 N22 GND sky130_fd_pr__nfet_01v8 l=0.5 w=5
XM11 N21 N9 VSS VDD sky130_fd_pr__pfet_01v8 l=0.5 w=5
XM12 N0 N7 N6 VDD sky130_fd_pr__pfet_01v8 l=0.5 w=5
XM13 N14 N17 N10 VDD sky130_fd_pr__pfet_01v8 l=0.5 w=5
XM14 N17 N0 N1 GND sky130_fd_pr__nfet_01v8 l=0.5 w=5
XM15 N9 N16 N21 VDD sky130_fd_pr__pfet_01v8 l=0.5 w=5
XM16 N16 N16 VSS VDD sky130_fd_pr__pfet_01v8 l=0.5 w=5
XM17 N18 N18 VSS VDD sky130_fd_pr__pfet_01v8 l=0.5 w=5
XM18 N14 IN_PLUS N20 GND sky130_fd_pr__nfet_01v8 l=0.5 w=5
XM19 N0 N0 LABEL_NET_3 GND sky130_fd_pr__nfet_01v8 l=0.5 w=5
XM20 N1 N1 LABEL_NET_4 GND sky130_fd_pr__nfet_01v8 l=0.5 w=5
XM21 N19 N16 VSS VDD sky130_fd_pr__pfet_01v8 l=0.5 w=5
XM22 N7 N0 N5 GND sky130_fd_pr__nfet_01v8 l=0.5 w=5
XM23 N18 N0 N5 GND sky130_fd_pr__nfet_01v8 l=0.5 w=5
XM24 N23 N23 VSS VDD sky130_fd_pr__pfet_01v8 l=0.5 w=5
XM25 N9 IN_MINUS N20 GND sky130_fd_pr__nfet_01v8 l=0.5 w=5
XM26 OUT N1 N11 GND sky130_fd_pr__nfet_01v8 l=0.5 w=5
XM27 N11 N19 N11 GND sky130_fd_pr__nfet_01v8 l=0.5 w=5
XM28 N17 N17 VSS VDD sky130_fd_pr__pfet_01v8 l=0.5 w=5
R1 N5 N5 10k
XM29 N7 N7 N23 VDD sky130_fd_pr__pfet_01v8 l=0.5 w=5

.control
set filetype=ascii

op
let vdd_current = abs(i(VVDD))
let power_dc = vdd_current * 1.8
print power_dc

ac dec 100 1 10g
let vout_mag = vm(OUT)
let gain_db = db(vout_mag)
let dc_gain_db = gain_db[0]
print dc_gain_db

if dc_gain_db > 0
    meas ac ugbw WHEN gain_db=0 CROSS=1
end

quit
.endc

.end
