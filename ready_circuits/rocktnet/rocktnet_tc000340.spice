* Testcase 000340 — Full Analysis (sky130 tt corner)
* SKY130 model header — replaces the ideal level-1 .model cards
* Ships with the demo; the paths point at the local sky130 PDK checkout.
* NOTE: libs.tech/ngspice/all.spice sets ".option scale=1.0u", so every
* instance L/W below is written in microns WITHOUT a "u" suffix.
.param mc_mm_switch=0
.param mc_pr_switch=0
.include /home/idies/workspace/Temporary/xyu1/scratch/skywater-pdk-libs-sky130_fd_pr/models/corners/tt.spice
.include /home/idies/workspace/Temporary/xyu1/scratch/skywater-pdk-libs-sky130_fd_pr/models/r+c/res_typical__cap_typical.spice
.include /home/idies/workspace/Temporary/xyu1/scratch/skywater-pdk-libs-sky130_fd_pr/models/r+c/res_typical__cap_typical__lin.spice
.include /home/idies/workspace/Temporary/xyu1/scratch/skywater-pdk-libs-sky130_fd_pr/models/corners/tt/specialized_cells.spice
.model DIDEAL D   is=1e-14 n=1
.options reltol=1e-3 itl1=500 itl2=100

* Sources
VVDD VDD 0 1.8
VIB IB 0 DC 0.9 AC 1

* Circuit
XM1 IFOUT LO180 N12 GND sky130_fd_pr__nfet_01v8 l=0.5 w=5
XN4 N11 Q N11 GND sky130_fd_pr__nfet_01v8 l=0.5 w=5
XM3 IFOUTB LO270 N11 GND sky130_fd_pr__nfet_01v8 l=0.5 w=5
I1 N2 GND 1u
I2 N11 GND 1u
XN3 N7 IB N2 GND sky130_fd_pr__nfet_01v8 l=0.5 w=5
XM5 IFOUTB LO0 N12 GND sky130_fd_pr__nfet_01v8 l=0.5 w=5
I3 N1 GND 1u
XM6 IFOUT LO0 N8 GND sky130_fd_pr__nfet_01v8 l=0.5 w=5
I4 N6 GND 1u
XN2 N8 IB N1 GND sky130_fd_pr__nfet_01v8 l=0.5 w=5
XM8 IFOUTB LO180 N8 GND sky130_fd_pr__nfet_01v8 l=0.5 w=5
XM9 IFOUT LO90 N11 GND sky130_fd_pr__nfet_01v8 l=0.5 w=5
XN1 N12 I N6 GND sky130_fd_pr__nfet_01v8 l=0.5 w=5
XM11 IFOUT LO270 N7 GND sky130_fd_pr__nfet_01v8 l=0.5 w=5
XM12 IFOUTB LO90 N7 GND sky130_fd_pr__nfet_01v8 l=0.5 w=5
R1 VDD IFOUTB 10k
R2 VDD IFOUT 10k
R3 N1 N6 10k
C1 VDD IFOUTB 1p
C2 VDD IFOUT 1p
R4 N2 N11 10k

.control
set filetype=ascii

op
let power_dc = abs(i(VVDD)) * 1.8
print power_dc

ac dec 100 1 10g
let gain_IFOUT = db(vm(IFOUT))
let gain_IFOUTB = db(vm(IFOUTB))
let gain_N8 = db(vm(N8))
let gain_LO180 = db(vm(LO180))
let gain_LO90 = db(vm(LO90))
meas ac max_gain_IFOUT MAX gain_IFOUT
meas ac max_gain_IFOUTB MAX gain_IFOUTB
meas ac max_gain_N8 MAX gain_N8
meas ac max_gain_LO180 MAX gain_LO180
meas ac max_gain_LO90 MAX gain_LO90

* Use first probe node for standard metrics
let gain_db = db(vm(IFOUT))
meas ac dc_gain_db FIND gain_db AT=1
meas ac ugbw WHEN gain_db=0 CROSS=1
let vout_dc = v(IFOUT)

print dc_gain_db ugbw vout_dc gain_IFOUT gain_IFOUTB gain_N8 gain_LO180 gain_LO90

quit
.endc

.end
