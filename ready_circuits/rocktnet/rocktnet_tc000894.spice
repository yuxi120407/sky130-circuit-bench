* Testcase 000894 — Full Analysis (sky130 tt corner)
* SKY130 model header — replaces the ideal level-1 .model cards
* Ships with the demo; the paths point at the local sky130 PDK checkout.
* NOTE: libs.tech/ngspice/all.spice sets ".option scale=1.0u", so every
* instance L/W below is written in microns WITHOUT a "u" suffix.
.param mc_mm_switch=0
.param mc_pr_switch=0
.include /home/idies/workspace/Temporary/xyu1/scratch/skywater-pdk-libs-sky130_fd_pr/models/corners/tt.spice
.include /home/idies/workspace/Temporary/xyu1/scratch/skywater-pdk-libs-sky130_fd_pr/models/r+c/res_typical__cap_typical.spice
.include /home/idies/workspace/Temporary/xyu1/scratch/skywater-pdk-libs-sky130_fd_pr/models/r+c/res_typical__cap_typical__lin.spice
.include /home/idies/workspace/Temporary/xyu1/scratch/skywater-pdk-libs-sky130_fd_pr/models/corners/tt/specialized_cells.spice
.model DIDEAL D   is=1e-14 n=1
.options reltol=1e-3 itl1=500 itl2=100

* Sources
VVDD VDD 0 1.8
VIBIAS IBIAS 0 0.75

* Circuit
XM1 N1 N2 VDD VDD sky130_fd_pr__pfet_01v8 l=0.5 w=5
XM2 N2 N2 VDD VDD sky130_fd_pr__pfet_01v8 l=0.5 w=5
XM3 IBIAS N2 VDD VDD sky130_fd_pr__pfet_01v8 l=0.5 w=5
XQP1 N1 N1 GND 0 sky130_fd_pr__npn_05v5_W1p00L1p00
XQP2 N2 N1 N3 0 sky130_fd_pr__npn_05v5_W1p00L1p00
XQP3 IBIAS IBIAS GND 0 sky130_fd_pr__npn_05v5_W1p00L1p00
R N3 GND 10k

.control
set filetype=ascii

op
let vdd_current = abs(i(VVDD))
let power_dc = vdd_current * 1.8
let vout_dc = v(N3)
print power_dc vout_dc

quit
.endc

.end
