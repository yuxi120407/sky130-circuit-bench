* Testcase 000435 — Full Analysis (sky130 tt corner)
* SKY130 model header — replaces the ideal level-1 .model cards
* Ships with the demo; the paths point at the local sky130 PDK checkout.
* NOTE: libs.tech/ngspice/all.spice sets ".option scale=1.0u", so every
* instance L/W below is written in microns WITHOUT a "u" suffix.
.param mc_mm_switch=0
.param mc_pr_switch=0
.include /home/idies/workspace/Temporary/xyu1/scratch/skywater-pdk-libs-sky130_fd_pr/models/corners/tt.spice
.include /home/idies/workspace/Temporary/xyu1/scratch/skywater-pdk-libs-sky130_fd_pr/models/r+c/res_typical__cap_typical.spice
.include /home/idies/workspace/Temporary/xyu1/scratch/skywater-pdk-libs-sky130_fd_pr/models/r+c/res_typical__cap_typical__lin.spice
.include /home/idies/workspace/Temporary/xyu1/scratch/skywater-pdk-libs-sky130_fd_pr/models/corners/tt/specialized_cells.spice
.model DIDEAL D   is=1e-14 n=1
.options reltol=1e-2 abstol=1e-10 vntol=1e-4 itl1=1000 itl2=200 itl4=100
.options gmin=1e-10 method=gear

* Sources
VVSS VSS 0 0

* Circuit
R2 N1 OUTP 10k
R1 N1 OUTN 10k
R3 N1 GND 10k
XM1 OUTP DCAP N3 VSS sky130_fd_pr__nfet_01v8 l=0.5 w=5
XM2 OUTP DINN N2 VSS sky130_fd_pr__nfet_01v8 l=0.5 w=5
XM3 N2 VOA VSS VSS sky130_fd_pr__nfet_01v8 l=0.5 w=5
XM4 N3 VSS VSS VSS sky130_fd_pr__nfet_01v8 l=0.5 w=5
XM5 OUTN DINP N2 VSS sky130_fd_pr__nfet_01v8 l=0.5 w=5
XM6 OUTN DCAN N3 VSS sky130_fd_pr__nfet_01v8 l=0.5 w=5

.control
set filetype=ascii

op
let power_dc = abs(i(VVSS)) * 1.8
print power_dc
let dc_voltage = v(N1)
print dc_voltage
print all

quit
.endc

.end
