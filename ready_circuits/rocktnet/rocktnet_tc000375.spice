* Testcase 000375 — Full Analysis (sky130 tt corner)
* SKY130 model header — replaces the ideal level-1 .model cards
* Ships with the demo; the paths point at the local sky130 PDK checkout.
* NOTE: libs.tech/ngspice/all.spice sets ".option scale=1.0u", so every
* instance L/W below is written in microns WITHOUT a "u" suffix.
.param mc_mm_switch=0
.param mc_pr_switch=0
.include /home/idies/workspace/Temporary/xyu1/scratch/skywater-pdk-libs-sky130_fd_pr/models/corners/tt.spice
.include /home/idies/workspace/Temporary/xyu1/scratch/skywater-pdk-libs-sky130_fd_pr/models/r+c/res_typical__cap_typical.spice
.include /home/idies/workspace/Temporary/xyu1/scratch/skywater-pdk-libs-sky130_fd_pr/models/r+c/res_typical__cap_typical__lin.spice
.include /home/idies/workspace/Temporary/xyu1/scratch/skywater-pdk-libs-sky130_fd_pr/models/corners/tt/specialized_cells.spice
.model DIDEAL D   is=1e-14 n=1
.options reltol=1e-3 itl1=500 itl2=100

* Sources
VVDD VDD 0 1.8
VVIN_PLUS VIN_PLUS 0 DC 0.9 AC 1 SIN(0.9 0.1 1MEG 0 0)
VLABEL_NET_1 LABEL_NET_1 0 0.9
VVCMSET VCMSET 0 DC 0.9 AC 1
VVIN_MINUS VIN_MINUS 0 DC 0.9 AC 1 SIN(0.9 0.1 1MEG 0 0)

* Circuit
XM9 N10 N1 GND GND sky130_fd_pr__nfet_01v8 l=0.5 w=5
XM5 N4 N11 N15 VDD sky130_fd_pr__pfet_01v8 l=0.5 w=5
XM_IN_P N12 VIN_PLUS N0 VDD sky130_fd_pr__pfet_01v8 l=0.5 w=5
XM10 N12 N1 GND GND sky130_fd_pr__nfet_01v8 l=0.5 w=5
XM_BIAS_N N1 N1 GND GND sky130_fd_pr__nfet_01v8 l=0.5 w=5
XMC1 N5 N4 VDD VDD sky130_fd_pr__pfet_01v8 l=0.5 w=5
XM3 N15 N9 VDD VDD sky130_fd_pr__pfet_01v8 l=0.5 w=5
XMC2_R N5 N3 VDD VDD sky130_fd_pr__pfet_01v8 l=0.5 w=5
XM8 N3 N7 N12 GND sky130_fd_pr__nfet_01v8 l=0.5 w=5
XM_BIAS_P LABEL_NET_1 LABEL_NET_1 VDD VDD sky130_fd_pr__pfet_01v8 l=0.5 w=5
XMC2_L N2 VCMSET VDD VDD sky130_fd_pr__pfet_01v8 l=0.5 w=5
XM7 N4 N7 N10 GND sky130_fd_pr__nfet_01v8 l=0.5 w=5
XM11 N0 N16 N5 VDD sky130_fd_pr__pfet_01v8 l=0.5 w=5
XM4 N14 N9 VDD VDD sky130_fd_pr__pfet_01v8 l=0.5 w=5
XM6 N3 N11 N14 VDD sky130_fd_pr__pfet_01v8 l=0.5 w=5
XM16 N1 N16 N2 VDD sky130_fd_pr__pfet_01v8 l=0.5 w=5
XMC3 N2 VCMSET VDD VDD sky130_fd_pr__pfet_01v8 l=0.5 w=5
XM18 N0 VIN_MINUS N10 GND sky130_fd_pr__nfet_01v8 l=0.5 w=5

.control
set filetype=ascii

op
let power_dc = abs(i(VVDD)) * 1.8
print power_dc

ac dec 100 1 10g
let gain_N2 = db(vm(N2))
let gain_N5 = db(vm(N5))
let gain_N11 = db(vm(N11))
let gain_N9 = db(vm(N9))
let gain_N4 = db(vm(N4))
meas ac max_gain_N2 MAX gain_N2
meas ac max_gain_N5 MAX gain_N5
meas ac max_gain_N11 MAX gain_N11
meas ac max_gain_N9 MAX gain_N9
meas ac max_gain_N4 MAX gain_N4

* Use first probe node for standard metrics
let gain_db = db(vm(N2))
meas ac dc_gain_db FIND gain_db AT=1
meas ac ugbw WHEN gain_db=0 CROSS=1
let vout_dc = v(N2)

print dc_gain_db ugbw vout_dc gain_N2 gain_N5 gain_N11 gain_N9 gain_N4

quit
.endc

.end
