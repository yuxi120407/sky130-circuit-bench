* Testcase 000393 — Full Analysis (sky130 tt corner)
* SKY130 model header — replaces the ideal level-1 .model cards
* Ships with the demo; the paths point at the local sky130 PDK checkout.
* NOTE: libs.tech/ngspice/all.spice sets ".option scale=1.0u", so every
* instance L/W below is written in microns WITHOUT a "u" suffix.
.param mc_mm_switch=0
.param mc_pr_switch=0
.include /home/idies/workspace/Temporary/xyu1/scratch/skywater-pdk-libs-sky130_fd_pr/models/corners/tt.spice
.include /home/idies/workspace/Temporary/xyu1/scratch/skywater-pdk-libs-sky130_fd_pr/models/r+c/res_typical__cap_typical.spice
.include /home/idies/workspace/Temporary/xyu1/scratch/skywater-pdk-libs-sky130_fd_pr/models/r+c/res_typical__cap_typical__lin.spice
.include /home/idies/workspace/Temporary/xyu1/scratch/skywater-pdk-libs-sky130_fd_pr/models/corners/tt/specialized_cells.spice
.model DIDEAL D   is=1e-14 n=1
.options reltol=1e-3 itl1=500 itl2=100

* Sources
VVDD VDD 0 1.8
VVSS VSS 0 DC 0 AC 0.5
VVBIAS VBIAS 0 0.9900000000000001

* Circuit
XMP5 N1 VBIAS VDD VDD sky130_fd_pr__pfet_01v8 l=0.5 w=5
XMP6 N2 VBIAS VDD VDD sky130_fd_pr__pfet_01v8 l=0.5 w=5
XMP7 VCNTRL VBIAS VDD VDD sky130_fd_pr__pfet_01v8 l=0.5 w=5
XMP1 N3 VOMIN N1 VDD sky130_fd_pr__pfet_01v8 l=0.5 w=5
XMP2 N4 VOMAX N1 VDD sky130_fd_pr__pfet_01v8 l=0.5 w=5
XMP3 N4 VIMIN N2 VDD sky130_fd_pr__pfet_01v8 l=0.5 w=5
XMP4 N3 VIMAX N2 VDD sky130_fd_pr__pfet_01v8 l=0.5 w=5
XMN1 N3 N3 VSS VSS sky130_fd_pr__nfet_01v8 l=0.5 w=5
XMN2 N4 N3 VSS VSS sky130_fd_pr__nfet_01v8 l=0.5 w=5
XMN3 VCNTRL N4 VSS VSS sky130_fd_pr__nfet_01v8 l=0.5 w=5
C1 N4 VCNTRL 1p

.control
set filetype=ascii

op
let power_dc = abs(i(VVDD)) * 1.8
print power_dc

ac dec 100 1 10g
let vout_mag = vm(N3)
let gain_db = db(vout_mag)
let dc_gain_db = gain_db[0]
print dc_gain_db

if dc_gain_db > 0
    meas ac ugbw WHEN gain_db=0 CROSS=1
    print ugbw
end

quit
.endc

.end
