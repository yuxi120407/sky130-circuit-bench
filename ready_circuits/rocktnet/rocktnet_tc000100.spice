* Testcase 000100 — Full Analysis (sky130 tt corner)
* SKY130 model header — replaces the ideal level-1 .model cards
* Ships with the demo; the paths point at the local sky130 PDK checkout.
* NOTE: libs.tech/ngspice/all.spice sets ".option scale=1.0u", so every
* instance L/W below is written in microns WITHOUT a "u" suffix.
.param mc_mm_switch=0
.param mc_pr_switch=0
.include /home/idies/workspace/Temporary/xyu1/scratch/skywater-pdk-libs-sky130_fd_pr/models/corners/tt.spice
.include /home/idies/workspace/Temporary/xyu1/scratch/skywater-pdk-libs-sky130_fd_pr/models/r+c/res_typical__cap_typical.spice
.include /home/idies/workspace/Temporary/xyu1/scratch/skywater-pdk-libs-sky130_fd_pr/models/r+c/res_typical__cap_typical__lin.spice
.include /home/idies/workspace/Temporary/xyu1/scratch/skywater-pdk-libs-sky130_fd_pr/models/corners/tt/specialized_cells.spice
.model DIDEAL D   is=1e-14 n=1
.options reltol=1e-3 itl1=500 itl2=100

* Sources
VLABEL_NET_0 LABEL_NET_0 0 DC 0.9 AC 0.5
VLABEL_NET_1 LABEL_NET_1 0 DC 0.9 AC -0.5
VLABEL_NET_2 LABEL_NET_2 0 0.9

* Circuit
I1 N3 GND 1u
L1 N3 N9 10n
L2 N3 N8 10n
L3 N6 N7 10n
C1 N6 N10 1p
L4 N7 GND 10n
L5 LABEL_NET_0 GND 10n
XQ1 N10 N2 N1 0 sky130_fd_pr__npn_05v5_W1p00L1p00
L6 N7 N10 10n
XQ2 N6 N2 N5 0 sky130_fd_pr__npn_05v5_W1p00L1p00
XQ3 N10 N0 N5 0 sky130_fd_pr__npn_05v5_W1p00L1p00
XQ4 N1 LABEL_NET_1 N8 0 sky130_fd_pr__npn_05v5_W1p00L1p00
R1 N2 N4 10k
R2 N0 N4 10k
L7 N0 N2 10n
XQ5 N5 LABEL_NET_2 N9 0 sky130_fd_pr__npn_05v5_W1p00L1p00
XQ6 N6 N0 N1 0 sky130_fd_pr__npn_05v5_W1p00L1p00

.control
set filetype=ascii

op
let power_dc = abs(i(VLABEL_NET_0)) * 1.8
print power_dc
let dc_voltage = v(N0)
print dc_voltage

quit
.endc

.end
