* Testcase 000621 — Full Analysis (sky130 tt corner)
* SKY130 model header — replaces the ideal level-1 .model cards
* Ships with the demo; the paths point at the local sky130 PDK checkout.
* NOTE: libs.tech/ngspice/all.spice sets ".option scale=1.0u", so every
* instance L/W below is written in microns WITHOUT a "u" suffix.
.param mc_mm_switch=0
.param mc_pr_switch=0
.include /home/idies/workspace/Temporary/xyu1/scratch/skywater-pdk-libs-sky130_fd_pr/models/corners/tt.spice
.include /home/idies/workspace/Temporary/xyu1/scratch/skywater-pdk-libs-sky130_fd_pr/models/r+c/res_typical__cap_typical.spice
.include /home/idies/workspace/Temporary/xyu1/scratch/skywater-pdk-libs-sky130_fd_pr/models/r+c/res_typical__cap_typical__lin.spice
.include /home/idies/workspace/Temporary/xyu1/scratch/skywater-pdk-libs-sky130_fd_pr/models/corners/tt/specialized_cells.spice
.model DIDEAL D   is=1e-14 n=1
.options reltol=1e-3 itl1=500 itl2=100

* Sources
VVDD VDD 0 1.8

* Circuit
XM1 VDD SR_B VDD VDD sky130_fd_pr__pfet_01v8 l=0.5 w=5
XM2 IC N5 N3 VDD sky130_fd_pr__pfet_01v8 l=0.5 w=5
XM3 VDD N3 VDD VDD sky130_fd_pr__pfet_01v8 l=0.5 w=5
XM4 N0 LSA GND GND sky130_fd_pr__nfet_01v8 l=0.5 w=5
XM5 N2 RS1 GND GND sky130_fd_pr__nfet_01v8 l=0.5 w=5
XM6 C3 N11 VDD VDD sky130_fd_pr__pfet_01v8 l=0.5 w=5
XM7 IC N7 N0 GND sky130_fd_pr__nfet_01v8 l=0.5 w=5
XM8 C3 N6 GND GND sky130_fd_pr__nfet_01v8 l=0.5 w=5
XM9 VDD RS0 SR_B GND sky130_fd_pr__nfet_01v8 l=0.5 w=5
XM10 N2 BCN N2 GND sky130_fd_pr__nfet_01v8 l=0.5 w=5
XM11 VDD IC T1 GND sky130_fd_pr__nfet_01v8 l=0.5 w=5
XM12 N6 IT GND GND sky130_fd_pr__nfet_01v8 l=0.5 w=5
XM13 QC VDD GND GND sky130_fd_pr__nfet_01v8 l=0.5 w=5
XM14 VDD VDD N3 GND sky130_fd_pr__nfet_01v8 l=0.5 w=5
XM15 IC VDD GND GND sky130_fd_pr__nfet_01v8 l=0.5 w=5
XM16 QT C3 GND GND sky130_fd_pr__nfet_01v8 l=0.5 w=5
XM17 IT VDD N0 GND sky130_fd_pr__nfet_01v8 l=0.5 w=5
XM18 N7 SR_B VDD VDD sky130_fd_pr__pfet_01v8 l=0.5 w=5
XM19 IT N7 GND GND sky130_fd_pr__nfet_01v8 l=0.5 w=5
XM20 VDD BTN N2 GND sky130_fd_pr__nfet_01v8 l=0.5 w=5
XM21 RS0 BC RS0 VDD sky130_fd_pr__pfet_01v8 l=0.5 w=5
XM22 IT N5 N11 VDD sky130_fd_pr__pfet_01v8 l=0.5 w=5
XM23 N11 N11 N6 VDD sky130_fd_pr__pfet_01v8 l=0.5 w=5
XM24 RS0 BT VDD VDD sky130_fd_pr__pfet_01v8 l=0.5 w=5

.control
set filetype=ascii

op
let vdd_current = abs(i(VVDD))
let power_dc = vdd_current * 1.8
print power_dc

print all

let vout_dc = v(IT)
print vout_dc
let vout_dc = v(QC)
print vout_dc
quit
.endc

.end
