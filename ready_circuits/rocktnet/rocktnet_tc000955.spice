* Testcase 000955 — Full Analysis (sky130 tt corner)
* SKY130 model header — replaces the ideal level-1 .model cards
* Ships with the demo; the paths point at the local sky130 PDK checkout.
* NOTE: libs.tech/ngspice/all.spice sets ".option scale=1.0u", so every
* instance L/W below is written in microns WITHOUT a "u" suffix.
.param mc_mm_switch=0
.param mc_pr_switch=0
.include /home/idies/workspace/Temporary/xyu1/scratch/skywater-pdk-libs-sky130_fd_pr/models/corners/tt.spice
.include /home/idies/workspace/Temporary/xyu1/scratch/skywater-pdk-libs-sky130_fd_pr/models/r+c/res_typical__cap_typical.spice
.include /home/idies/workspace/Temporary/xyu1/scratch/skywater-pdk-libs-sky130_fd_pr/models/r+c/res_typical__cap_typical__lin.spice
.include /home/idies/workspace/Temporary/xyu1/scratch/skywater-pdk-libs-sky130_fd_pr/models/corners/tt/specialized_cells.spice
.model DIDEAL D   is=1e-14 n=1
.options reltol=1e-3 itl1=500 itl2=100

* Sources
VVDD VDD 0 1.8
VLABEL_NET_0 LABEL_NET_0 0 0.9
VLABEL_NET_2 LABEL_NET_2 0 0.9

* Circuit
R1 N4 GND 10k
R2 N2 GND 10k
XM1 GND LABEL_NET_0 VDD VDD sky130_fd_pr__pfet_01v8 l=0.5 w=5
R3 N0 N4 10k
R4 N1 N3 10k
R5 N1 GND 10k
R6 N0 N3 10k
R7 GND GND 10k
R8 LABEL_NET_2 GND 10k

.control
set filetype=ascii

op
let power_dc = abs(i(VVDD)) * 1.8
print power_dc
let dc_voltage_10k = v(10k)
print dc_voltage_10k
let dc_voltage_N0 = v(N0)
print dc_voltage_N0
let dc_voltage_N1 = v(N1)
print dc_voltage_N1
let dc_voltage_N2 = v(N2)
print dc_voltage_N2
let dc_voltage_N3 = v(N3)
print dc_voltage_N3

quit
.endc

.end
