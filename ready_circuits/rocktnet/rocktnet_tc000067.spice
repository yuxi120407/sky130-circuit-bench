* Testcase 000067 — Full Analysis (sky130 tt corner)
* SKY130 model header — replaces the ideal level-1 .model cards
* Ships with the demo; the paths point at the local sky130 PDK checkout.
* NOTE: libs.tech/ngspice/all.spice sets ".option scale=1.0u", so every
* instance L/W below is written in microns WITHOUT a "u" suffix.
.param mc_mm_switch=0
.param mc_pr_switch=0
.include /home/idies/workspace/Temporary/xyu1/scratch/skywater-pdk-libs-sky130_fd_pr/models/corners/tt.spice
.include /home/idies/workspace/Temporary/xyu1/scratch/skywater-pdk-libs-sky130_fd_pr/models/r+c/res_typical__cap_typical.spice
.include /home/idies/workspace/Temporary/xyu1/scratch/skywater-pdk-libs-sky130_fd_pr/models/r+c/res_typical__cap_typical__lin.spice
.include /home/idies/workspace/Temporary/xyu1/scratch/skywater-pdk-libs-sky130_fd_pr/models/corners/tt/specialized_cells.spice
.model DIDEAL D   is=1e-14 n=1
.options reltol=1e-3 itl1=500 itl2=100

* Sources
VVDD VDD 0 1.8

* Circuit
XM1 N5 N1 VDD VDD sky130_fd_pr__pfet_01v8 l=0.5 w=5
I1 VDD N2 1u
XM2 N3 N9 N8 GND sky130_fd_pr__nfet_01v8 l=0.5 w=5
XM3 N8 N0 GND GND sky130_fd_pr__nfet_01v8 l=0.5 w=5
XM4 N2 N2 GND GND sky130_fd_pr__nfet_01v8 l=0.5 w=5
XM5 N1 N10 N8 GND sky130_fd_pr__nfet_01v8 l=0.5 w=5
XM6 N4 N3 VDD VDD sky130_fd_pr__pfet_01v8 l=0.5 w=5
XM7 N3 N10 N7 GND sky130_fd_pr__nfet_01v8 l=0.5 w=5
XM8 N1 N9 N7 GND sky130_fd_pr__nfet_01v8 l=0.5 w=5
XM9 N7 N6 GND GND sky130_fd_pr__nfet_01v8 l=0.5 w=5
R1 VDD N3 10k
R2 VDD N1 10k
C1 N6 N0 1p
C2 N0 N6 1p
R3 N5 GND 10k
R4 N4 GND 10k
R5 N2 GND 10k
R6 N2 N8 10k
C3 N2 GND 1p

.control
set filetype=ascii

op
let vdd_current = abs(i(VVDD))
let power_dc = vdd_current * 1.8
print power_dc

ac dec 100 1 10g
let vout_mag = vm(N5)
let gain_db = db(vout_mag)
let dc_gain_db = gain_db[0]
print dc_gain_db

if dc_gain_db > 0
    meas ac ugbw WHEN gain_db=0 CROSS=1
end

quit
.endc

.end
