* Testcase 000565 — Full Analysis (sky130 tt corner)
* SKY130 model header — replaces the ideal level-1 .model cards
* Ships with the demo; the paths point at the local sky130 PDK checkout.
* NOTE: libs.tech/ngspice/all.spice sets ".option scale=1.0u", so every
* instance L/W below is written in microns WITHOUT a "u" suffix.
.param mc_mm_switch=0
.param mc_pr_switch=0
.include /home/idies/workspace/Temporary/xyu1/scratch/skywater-pdk-libs-sky130_fd_pr/models/corners/tt.spice
.include /home/idies/workspace/Temporary/xyu1/scratch/skywater-pdk-libs-sky130_fd_pr/models/r+c/res_typical__cap_typical.spice
.include /home/idies/workspace/Temporary/xyu1/scratch/skywater-pdk-libs-sky130_fd_pr/models/r+c/res_typical__cap_typical__lin.spice
.include /home/idies/workspace/Temporary/xyu1/scratch/skywater-pdk-libs-sky130_fd_pr/models/corners/tt/specialized_cells.spice
.model DIDEAL D   is=1e-14 n=1
.options reltol=1e-3 itl1=500 itl2=100

* Sources
VVDD VDD 0 1.8

* Circuit
I1 N0 GND 1u
I2 VDD GND 1u
I3 N8 GND 1u
I4 N3 GND 1u
XM1 GND N6 N0 GND sky130_fd_pr__nfet_01v8 l=0.5 w=5
I5 N4 GND 1u
I6 N4 N6 1u
I7 N12 GND 1u
I8 N5 GND 1u
I9 VDD N1 1u
XM2 GND N17 N9 VDD sky130_fd_pr__pfet_01v8 l=0.5 w=5
I10 GND GND 1u
I11 GND GND 1u
XM3 N2 GND GND VDD sky130_fd_pr__pfet_01v8 l=0.5 w=5
XM4 N6 N0 GND GND sky130_fd_pr__nfet_01v8 l=0.5 w=5
XM5 N19 N18 GND GND sky130_fd_pr__nfet_01v8 l=0.5 w=5
XM6 N13 N18 GND GND sky130_fd_pr__nfet_01v8 l=0.5 w=5
XM7 GND GND VDD VDD sky130_fd_pr__pfet_01v8 l=0.5 w=5
XM8 GND N1 N3 GND sky130_fd_pr__nfet_01v8 l=0.5 w=5
XM9 GND GND N12 GND sky130_fd_pr__nfet_01v8 l=0.5 w=5
XM10 N7 N14 N8 GND sky130_fd_pr__nfet_01v8 l=0.5 w=5
XM11 N1 N3 GND GND sky130_fd_pr__nfet_01v8 l=0.5 w=5
XM12 VDD GND GND GND sky130_fd_pr__nfet_01v8 l=0.5 w=5
XM13 N14 N16 GND VDD sky130_fd_pr__pfet_01v8 l=0.5 w=5
XM14 N10 N2 N5 GND sky130_fd_pr__nfet_01v8 l=0.5 w=5
XM15 GND GND N12 GND sky130_fd_pr__nfet_01v8 l=0.5 w=5
XM16 GND GND N9 VDD sky130_fd_pr__pfet_01v8 l=0.5 w=5
R1 N10 N15 10k
R2 N7 N11 10k
XM17 GND GND VDD VDD sky130_fd_pr__pfet_01v8 l=0.5 w=5
XM18 N14 N19 N13 GND sky130_fd_pr__nfet_01v8 l=0.5 w=5
XM19 N2 N19 N18 GND sky130_fd_pr__nfet_01v8 l=0.5 w=5
D1 N0 VDD DIDEAL
L1 N9 N15 10n
XM20 GND GND VDD VDD sky130_fd_pr__pfet_01v8 l=0.5 w=5
R3 N9 N11 10k

.control
set filetype=ascii

op
let vdd_current = abs(i(VVDD))
let power_dc = vdd_current * 1.8
print power_dc

print all

let vout_dc = v(N14)
print vout_dc
let vout_dc = v(N2)
print vout_dc
quit
.endc

.end
