* Testcase 000763 — Full Analysis (sky130 tt corner)
* SKY130 model header — replaces the ideal level-1 .model cards
* Ships with the demo; the paths point at the local sky130 PDK checkout.
* NOTE: libs.tech/ngspice/all.spice sets ".option scale=1.0u", so every
* instance L/W below is written in microns WITHOUT a "u" suffix.
.param mc_mm_switch=0
.param mc_pr_switch=0
.include /home/idies/workspace/Temporary/xyu1/scratch/skywater-pdk-libs-sky130_fd_pr/models/corners/tt.spice
.include /home/idies/workspace/Temporary/xyu1/scratch/skywater-pdk-libs-sky130_fd_pr/models/r+c/res_typical__cap_typical.spice
.include /home/idies/workspace/Temporary/xyu1/scratch/skywater-pdk-libs-sky130_fd_pr/models/r+c/res_typical__cap_typical__lin.spice
.include /home/idies/workspace/Temporary/xyu1/scratch/skywater-pdk-libs-sky130_fd_pr/models/corners/tt/specialized_cells.spice
.model DIDEAL D   is=1e-14 n=1
.options reltol=1e-3 itl1=500 itl2=100

* Sources
VVDD VDD 0 1.8
VLABEL_NET_0 LABEL_NET_0 0 0.9
VVCTRL_N VCTRL_N 0 0.9
VVCTRL_P VCTRL_P 0 0.9

* Circuit
I1 N3 GND 1u
I2 N5 GND 1u
XM1 ICTRL N0 N6 VDD sky130_fd_pr__pfet_01v8 l=0.5 w=5
XM3 N0 N0 N6 VDD sky130_fd_pr__pfet_01v8 l=0.5 w=5
I3 N4 GND 1u
XM2 N1 N1 N6 VDD sky130_fd_pr__pfet_01v8 l=0.5 w=5
R1 N10 GND 10k
R2 LABEL_NET_0 GND 10k
XM4 N7 N1 N6 VDD sky130_fd_pr__pfet_01v8 l=0.5 w=5
R3 N4 N5 10k
XQ4 N1 N8 N3 0 sky130_fd_pr__npn_05v5_W1p00L1p00
XQ2 N8 VCTRL_N N5 0 sky130_fd_pr__npn_05v5_W1p00L1p00
XQ3 N6 N6 N2 0 sky130_fd_pr__npn_05v5_W1p00L1p00
XQ1 N0 N2 N3 0 sky130_fd_pr__npn_05v5_W1p00L1p00
XQ5 N6 N6 N8 0 sky130_fd_pr__npn_05v5_W1p00L1p00
XQ6 N2 VCTRL_P N4 0 sky130_fd_pr__npn_05v5_W1p00L1p00
XQ7 ICTRL N7 GND 0 sky130_fd_pr__npn_05v5_W1p00L1p00
XQ8 N7 N7 N10 0 sky130_fd_pr__npn_05v5_W1p00L1p00

.control
set filetype=ascii

op
let vdd_current = abs(i(VVDD))
let power_dc = vdd_current * 1.8
let vout_dc = v(N10)
print power_dc vout_dc

quit
.endc

.end
