* Testcase 000687 — Full Analysis (sky130 tt corner)
* SKY130 model header — replaces the ideal level-1 .model cards
* Ships with the demo; the paths point at the local sky130 PDK checkout.
* NOTE: libs.tech/ngspice/all.spice sets ".option scale=1.0u", so every
* instance L/W below is written in microns WITHOUT a "u" suffix.
.param mc_mm_switch=0
.param mc_pr_switch=0
.include /home/idies/workspace/Temporary/xyu1/scratch/skywater-pdk-libs-sky130_fd_pr/models/corners/tt.spice
.include /home/idies/workspace/Temporary/xyu1/scratch/skywater-pdk-libs-sky130_fd_pr/models/r+c/res_typical__cap_typical.spice
.include /home/idies/workspace/Temporary/xyu1/scratch/skywater-pdk-libs-sky130_fd_pr/models/r+c/res_typical__cap_typical__lin.spice
.include /home/idies/workspace/Temporary/xyu1/scratch/skywater-pdk-libs-sky130_fd_pr/models/corners/tt/specialized_cells.spice
.model DIDEAL D   is=1e-14 n=1
.options reltol=1e-3 itl1=500 itl2=100

* Sources
VVDD VDD 0 1.8
VVBN VBN 0 0.54
VVINN VINN 0 DC 0.9 AC 1 SIN(0.9 0.1 1MEG 0 0)
VVINP VINP 0 DC 0.9 AC 1 SIN(0.9 0.1 1MEG 0 0)
VVBP VBP 0 0.9900000000000001

* Circuit
XM1 N4 VBN GND GND sky130_fd_pr__nfet_01v8 l=0.5 w=5
XM2 N4 VINN N2 VDD sky130_fd_pr__pfet_01v8 l=0.5 w=5
XM3 N3 VINP N1 VDD sky130_fd_pr__pfet_01v8 l=0.5 w=5
XM4 VOUTN N4 GND GND sky130_fd_pr__nfet_01v8 l=0.5 w=5
XM5 VOUTP N3 GND GND sky130_fd_pr__nfet_01v8 l=0.5 w=5
XM6 VOUTP VBP VDD VDD sky130_fd_pr__pfet_01v8 l=0.5 w=5
XM7 VOUTN VBP VDD VDD sky130_fd_pr__pfet_01v8 l=0.5 w=5
XM8 N3 VBN GND GND sky130_fd_pr__nfet_01v8 l=0.5 w=5
XM9 N2 VBP VDD VDD sky130_fd_pr__pfet_01v8 l=0.5 w=5
XM10 N1 VBP VDD VDD sky130_fd_pr__pfet_01v8 l=0.5 w=5
R1 N2 VOUTN 10k
R2 VOUTP N1 10k
R3 N1 N2 10k

.control
set filetype=ascii

op
let vdd_current = abs(i(VVDD))
let power_dc = vdd_current * 1.8
print power_dc

print all

quit
.endc

.end
