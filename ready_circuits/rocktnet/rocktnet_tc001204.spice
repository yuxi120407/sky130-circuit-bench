* Testcase 001204 — Full Analysis (sky130 tt corner)
* SKY130 model header — replaces the ideal level-1 .model cards
* Ships with the demo; the paths point at the local sky130 PDK checkout.
* NOTE: libs.tech/ngspice/all.spice sets ".option scale=1.0u", so every
* instance L/W below is written in microns WITHOUT a "u" suffix.
.param mc_mm_switch=0
.param mc_pr_switch=0
.include /home/idies/workspace/Temporary/xyu1/scratch/skywater-pdk-libs-sky130_fd_pr/models/corners/tt.spice
.include /home/idies/workspace/Temporary/xyu1/scratch/skywater-pdk-libs-sky130_fd_pr/models/r+c/res_typical__cap_typical.spice
.include /home/idies/workspace/Temporary/xyu1/scratch/skywater-pdk-libs-sky130_fd_pr/models/r+c/res_typical__cap_typical__lin.spice
.include /home/idies/workspace/Temporary/xyu1/scratch/skywater-pdk-libs-sky130_fd_pr/models/corners/tt/specialized_cells.spice
.model DIDEAL D   is=1e-14 n=1
.options reltol=1e-3 itl1=500 itl2=100

* Sources
VVDD VDD 0 1.8
VVBB VBB 0 0.9900000000000001
VVINP VINP 0 DC 0.9 AC 1 SIN(0.9 0.1 1MEG 0 0)
VVINN VINN 0 DC 0.9 AC 1 SIN(0.9 0.1 1MEG 0 0)

* Circuit
XM2 N10 N02 N13 GND sky130_fd_pr__nfet_01v8 l=0.5 w=5
XM3 VOUTP VGG N8 VDD sky130_fd_pr__pfet_01v8 l=0.5 w=5
XM1 N14 N01 N13 GND sky130_fd_pr__nfet_01v8 l=0.5 w=5
XM4 VOUTN N12 N10 GND sky130_fd_pr__nfet_01v8 l=0.5 w=5
XM5 VOUTN N7 N11 VDD sky130_fd_pr__pfet_01v8 l=0.5 w=5
XM6 N8 VBB VDD VDD sky130_fd_pr__pfet_01v8 l=0.5 w=5
XM7 VOUTP VGG N14 GND sky130_fd_pr__nfet_01v8 l=0.5 w=5
C2 N3 N02 1p
C1 N2 N01 1p
XM8 N11 N6 VDD VDD sky130_fd_pr__pfet_01v8 l=0.5 w=5

.control
set filetype=ascii

op
let vdd_current = abs(i(VVDD))
let power_dc = vdd_current * 1.8
print power_dc

print all

quit
.endc

.end
