* Testcase 000666 — Full Analysis (sky130 tt corner)
* SKY130 model header — replaces the ideal level-1 .model cards
* Ships with the demo; the paths point at the local sky130 PDK checkout.
* NOTE: libs.tech/ngspice/all.spice sets ".option scale=1.0u", so every
* instance L/W below is written in microns WITHOUT a "u" suffix.
.param mc_mm_switch=0
.param mc_pr_switch=0
.include /home/idies/workspace/Temporary/xyu1/scratch/skywater-pdk-libs-sky130_fd_pr/models/corners/tt.spice
.include /home/idies/workspace/Temporary/xyu1/scratch/skywater-pdk-libs-sky130_fd_pr/models/r+c/res_typical__cap_typical.spice
.include /home/idies/workspace/Temporary/xyu1/scratch/skywater-pdk-libs-sky130_fd_pr/models/r+c/res_typical__cap_typical__lin.spice
.include /home/idies/workspace/Temporary/xyu1/scratch/skywater-pdk-libs-sky130_fd_pr/models/corners/tt/specialized_cells.spice
.model DIDEAL D   is=1e-14 n=1
.options reltol=1e-3 itl1=500 itl2=100

* Sources
VVDD VDD 0 1.8
VVSS VSS 0 DC 0 AC 0.5

* Circuit
XM1 N1 VX N3 VDD sky130_fd_pr__pfet_01v8 l=0.5 w=5
XM2 N2 VY N3 VDD sky130_fd_pr__pfet_01v8 l=0.5 w=5
XM3 N1 N1 VSS VSS sky130_fd_pr__nfet_01v8 l=0.5 w=5
XM4 N2 N2 VSS VSS sky130_fd_pr__nfet_01v8 l=0.5 w=5
XM5 N5 N1 VSS VSS sky130_fd_pr__nfet_01v8 l=0.5 w=5
XM6 N4 N4 VSS VSS sky130_fd_pr__nfet_01v8 l=0.5 w=5
XM7 VO1 N4 N5 VSS sky130_fd_pr__nfet_01v8 l=0.5 w=5
XM8 N7 N2 VSS VSS sky130_fd_pr__nfet_01v8 l=0.5 w=5
XM9 N6 N6 VSS VSS sky130_fd_pr__nfet_01v8 l=0.5 w=5
XM10 VO2 N6 N7 VSS sky130_fd_pr__nfet_01v8 l=0.5 w=5
XM11 VO1 VO1 VDD VDD sky130_fd_pr__pfet_01v8 l=0.5 w=5
XM12 VO2 VO1 VDD VDD sky130_fd_pr__pfet_01v8 l=0.5 w=5
C VO1 VO2 1p
I1 VDD N6 1u
I2 VDD N4 1u
I5 VDD N3 1u

.control
set filetype=ascii

op
let power_dc = abs(i(VVDD)) * 1.8
print power_dc

ac dec 100 1 10g
let vout_mag = vm(N1)
let gain_db = db(vout_mag)
let dc_gain_db = gain_db[0]
print dc_gain_db

if dc_gain_db > 0
    meas ac ugbw WHEN gain_db=0 CROSS=1
    print ugbw
end

quit
.endc

.end
