* Testcase 000050 — Full Analysis (sky130 tt corner)
* SKY130 model header — replaces the ideal level-1 .model cards
* Ships with the demo; the paths point at the local sky130 PDK checkout.
* NOTE: libs.tech/ngspice/all.spice sets ".option scale=1.0u", so every
* instance L/W below is written in microns WITHOUT a "u" suffix.
.param mc_mm_switch=0
.param mc_pr_switch=0
.include /home/idies/workspace/Temporary/xyu1/scratch/skywater-pdk-libs-sky130_fd_pr/models/corners/tt.spice
.include /home/idies/workspace/Temporary/xyu1/scratch/skywater-pdk-libs-sky130_fd_pr/models/r+c/res_typical__cap_typical.spice
.include /home/idies/workspace/Temporary/xyu1/scratch/skywater-pdk-libs-sky130_fd_pr/models/r+c/res_typical__cap_typical__lin.spice
.include /home/idies/workspace/Temporary/xyu1/scratch/skywater-pdk-libs-sky130_fd_pr/models/corners/tt/specialized_cells.spice
.model DIDEAL D   is=1e-14 n=1
.options reltol=1e-3 itl1=500 itl2=100

* Sources
VVDD VDD 0 1.8
VLABEL_NET_0 LABEL_NET_0 0 0.9
VLABEL_NET_1 LABEL_NET_1 0 0.9
VLABEL_NET_2 LABEL_NET_2 0 0.9
VLABEL_NET_3 LABEL_NET_3 0 0.9
VLABEL_NET_4 LABEL_NET_4 0 0.9
VLABEL_NET_5 LABEL_NET_5 0 0.9

* Circuit
XM1 N4 N9 N3 GND sky130_fd_pr__nfet_01v8 l=0.5 w=5
XM2 N0 N0 N3 GND sky130_fd_pr__nfet_01v8 l=0.5 w=5
XM3 N6 N11 VDD VDD sky130_fd_pr__pfet_01v8 l=0.5 w=5
XM4 N2 N0 N3 GND sky130_fd_pr__nfet_01v8 l=0.5 w=5
I1 N5 N3 1u
XM5 N12 N15 N2 GND sky130_fd_pr__nfet_01v8 l=0.5 w=5
XM6 N7 N7 VDD VDD sky130_fd_pr__pfet_01v8 l=0.5 w=5
I2 N1 N3 1u
XM7 N12 N19 N8 VDD sky130_fd_pr__pfet_01v8 l=0.5 w=5
XM8 N10 N9 N3 GND sky130_fd_pr__nfet_01v8 l=0.5 w=5
XM9 N11 N11 VDD VDD sky130_fd_pr__pfet_01v8 l=0.5 w=5
XM10 N1 N1 N14 VDD sky130_fd_pr__pfet_01v8 l=0.5 w=5
XM11 N8 N7 VDD VDD sky130_fd_pr__pfet_01v8 l=0.5 w=5
XM12 N0 N21 N23 VDD sky130_fd_pr__pfet_01v8 l=0.5 w=5
XM13 N17 N13 N6 VDD sky130_fd_pr__pfet_01v8 l=0.5 w=5
XM14 N17 N18 N4 GND sky130_fd_pr__nfet_01v8 l=0.5 w=5
XM15 N10 N24 N23 VDD sky130_fd_pr__pfet_01v8 l=0.5 w=5
XM16 N7 N22 N23 GND sky130_fd_pr__nfet_01v8 l=0.5 w=5
XM17 N11 N20 N23 GND sky130_fd_pr__nfet_01v8 l=0.5 w=5
XM18 VDD LABEL_NET_4 N14 GND sky130_fd_pr__nfet_01v8 l=0.5 w=5
XM19 VDD LABEL_NET_5 N16 GND sky130_fd_pr__nfet_01v8 l=0.5 w=5
XM20 N5 N5 N16 VDD sky130_fd_pr__pfet_01v8 l=0.5 w=5

.control
set filetype=ascii

op
let vdd_current = abs(i(VVDD))
let power_dc = vdd_current * 1.8
print power_dc

print all

let vout_dc = v(N11)
print vout_dc
let vout_dc = v(N24)
print vout_dc
quit
.endc

.end
