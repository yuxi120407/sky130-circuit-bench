* Testcase 000893 — Full Analysis (sky130 tt corner)
* SKY130 model header — replaces the ideal level-1 .model cards
* Ships with the demo; the paths point at the local sky130 PDK checkout.
* NOTE: libs.tech/ngspice/all.spice sets ".option scale=1.0u", so every
* instance L/W below is written in microns WITHOUT a "u" suffix.
.param mc_mm_switch=0
.param mc_pr_switch=0
.include /home/idies/workspace/Temporary/xyu1/scratch/skywater-pdk-libs-sky130_fd_pr/models/corners/tt.spice
.include /home/idies/workspace/Temporary/xyu1/scratch/skywater-pdk-libs-sky130_fd_pr/models/r+c/res_typical__cap_typical.spice
.include /home/idies/workspace/Temporary/xyu1/scratch/skywater-pdk-libs-sky130_fd_pr/models/r+c/res_typical__cap_typical__lin.spice
.include /home/idies/workspace/Temporary/xyu1/scratch/skywater-pdk-libs-sky130_fd_pr/models/corners/tt/specialized_cells.spice
.model DIDEAL D   is=1e-14 n=1
.options reltol=1e-3 itl1=500 itl2=100

* Sources
VVDD VDD 0 1.8
VVIN VIN 0 DC 0.9 AC 1 SIN(0.9 0.1 1MEG 0 0)
VVIN2 VIN2 0 DC 0.9 AC 1 SIN(0.9 0.1 1MEG 0 0)

* Circuit
XQ2 VOUT_PLUS VIN N_EMIT 0 sky130_fd_pr__npn_05v5_W1p00L1p00
XQ3 VOUT_MINUS VIN2 N_EMIT 0 sky130_fd_pr__npn_05v5_W1p00L1p00
CE2 N_EMIT GND 1p
LC2 VDD VOUT_PLUS 10n
LC3 VDD VOUT_MINUS 10n
V1 VOUT_PLUS VOUT_P 0
LE2 N_EMIT GND 10n
V2 VOUT_N VOUT_MINUS 0

.control
set filetype=ascii

op
let vdd_current = abs(i(VVDD))
let power_dc = vdd_current * 1.8
print power_dc

ac dec 100 1k 100g
let vout_mag = vm(N_EMIT)
let gain_db = db(vout_mag)

meas ac max_gain_db MAX gain_db
meas ac bw_3db WHEN gain_db='max_gain_db-3' CROSS=1

print max_gain_db bw_3db

quit
.endc

.end
