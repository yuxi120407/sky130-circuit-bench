* Testcase 000766 — Full Analysis (sky130 tt corner)
* SKY130 model header — replaces the ideal level-1 .model cards
* Ships with the demo; the paths point at the local sky130 PDK checkout.
* NOTE: libs.tech/ngspice/all.spice sets ".option scale=1.0u", so every
* instance L/W below is written in microns WITHOUT a "u" suffix.
.param mc_mm_switch=0
.param mc_pr_switch=0
.include /home/idies/workspace/Temporary/xyu1/scratch/skywater-pdk-libs-sky130_fd_pr/models/corners/tt.spice
.include /home/idies/workspace/Temporary/xyu1/scratch/skywater-pdk-libs-sky130_fd_pr/models/r+c/res_typical__cap_typical.spice
.include /home/idies/workspace/Temporary/xyu1/scratch/skywater-pdk-libs-sky130_fd_pr/models/r+c/res_typical__cap_typical__lin.spice
.include /home/idies/workspace/Temporary/xyu1/scratch/skywater-pdk-libs-sky130_fd_pr/models/corners/tt/specialized_cells.spice
.model DIDEAL D   is=1e-14 n=1
.options reltol=1e-2 abstol=1e-10 vntol=1e-4 itl1=1000 itl2=200 itl4=100
.options gmin=1e-10 method=gear

* Sources
VLABEL_NET_0 LABEL_NET_0 0 0.9
VLABEL_NET_1 LABEL_NET_1 0 0.9
VLABEL_NET_2 LABEL_NET_2 0 0.9
VLABEL_NET_3 LABEL_NET_3 0 0.9
VLABEL_NET_4 LABEL_NET_4 0 0.9
VLABEL_NET_5 LABEL_NET_5 0 0.9
VLABEL_NET_6 LABEL_NET_6 0 0.9
VLABEL_NET_7 LABEL_NET_7 0 0.9
VLABEL_NET_8 LABEL_NET_8 0 0.9

* Circuit
XQ1 N0 LABEL_NET_0 N5 0 sky130_fd_pr__npn_05v5_W1p00L1p00
XQ2 N0 LABEL_NET_1 N2 0 sky130_fd_pr__npn_05v5_W1p00L1p00
R1 N2 N3 10k
R2 N3 N5 10k
XQ3 LABEL_NET_2 N0 N8 0 sky130_fd_pr__npn_05v5_W1p00L1p00
XQ4 LABEL_NET_3 N0 N7 0 sky130_fd_pr__npn_05v5_W1p00L1p00
R3 N0 LABEL_NET_4 10k
XQ5 N1 N1 N6 0 sky130_fd_pr__npn_05v5_W1p00L1p00
R4 N0 LABEL_NET_5 10k
R5 N7 LABEL_NET_6 10k
R6 N1 LABEL_NET_7 10k
R7 N8 LABEL_NET_8 10k
R8 N4 GND 10k
R9 N6 GND 10k
XQ6 N3 N1 N4 0 sky130_fd_pr__npn_05v5_W1p00L1p00

.control
set filetype=ascii

op
let power_dc = abs(i(VLABEL_NET_0)) * 1.8
print power_dc
let dc_voltage = v(N0)
print dc_voltage
print all

quit
.endc

.end
