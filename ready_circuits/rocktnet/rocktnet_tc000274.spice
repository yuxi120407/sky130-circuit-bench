* Testcase 000274 — Full Analysis (sky130 tt corner)
* SKY130 model header — replaces the ideal level-1 .model cards
* Ships with the demo; the paths point at the local sky130 PDK checkout.
* NOTE: libs.tech/ngspice/all.spice sets ".option scale=1.0u", so every
* instance L/W below is written in microns WITHOUT a "u" suffix.
.param mc_mm_switch=0
.param mc_pr_switch=0
.include /home/idies/workspace/Temporary/xyu1/scratch/skywater-pdk-libs-sky130_fd_pr/models/corners/tt.spice
.include /home/idies/workspace/Temporary/xyu1/scratch/skywater-pdk-libs-sky130_fd_pr/models/r+c/res_typical__cap_typical.spice
.include /home/idies/workspace/Temporary/xyu1/scratch/skywater-pdk-libs-sky130_fd_pr/models/r+c/res_typical__cap_typical__lin.spice
.include /home/idies/workspace/Temporary/xyu1/scratch/skywater-pdk-libs-sky130_fd_pr/models/corners/tt/specialized_cells.spice
.model DIDEAL D   is=1e-14 n=1
.options reltol=1e-3 itl1=500 itl2=100

* Sources
VVIN VIN 0 DC 0.9 AC 1 SIN(0.9 0.1 1MEG 0 0)

* Circuit
C2 VIN N1 1p
C1 VOUT GND 1p

.control
set filetype=ascii

op
let power_dc = abs(i(VVIN)) * 1.8
print power_dc

ac dec 100 1 100g

let probe_mag = vm(N1)
let probe_db = db(probe_mag)

meas ac peak_gain_db MAX probe_db
meas ac peak_freq WHEN probe_db=peak_gain_db CROSS=1
meas ac cutoff_freq WHEN probe_db='peak_gain_db-3' CROSS=1

print peak_gain_db peak_freq cutoff_freq

quit
.endc

.end
