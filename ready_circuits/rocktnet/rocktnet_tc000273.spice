* Testcase 000273 — Full Analysis (sky130 tt corner)
* SKY130 model header — replaces the ideal level-1 .model cards
* Ships with the demo; the paths point at the local sky130 PDK checkout.
* NOTE: libs.tech/ngspice/all.spice sets ".option scale=1.0u", so every
* instance L/W below is written in microns WITHOUT a "u" suffix.
.param mc_mm_switch=0
.param mc_pr_switch=0
.include /home/idies/workspace/Temporary/xyu1/scratch/skywater-pdk-libs-sky130_fd_pr/models/corners/tt.spice
.include /home/idies/workspace/Temporary/xyu1/scratch/skywater-pdk-libs-sky130_fd_pr/models/r+c/res_typical__cap_typical.spice
.include /home/idies/workspace/Temporary/xyu1/scratch/skywater-pdk-libs-sky130_fd_pr/models/r+c/res_typical__cap_typical__lin.spice
.include /home/idies/workspace/Temporary/xyu1/scratch/skywater-pdk-libs-sky130_fd_pr/models/corners/tt/specialized_cells.spice
.model DIDEAL D   is=1e-14 n=1
.options reltol=1e-3 itl1=500 itl2=100

* Sources
VVDD VDD 0 1.8

* Circuit
I1 N1 GND 1u
I2 N2 GND 1u
R1 VDD SQ_OUT 10k
R2 VDD SQ_OUTB 10k
XM1 N3 I_OUT2 N1 GND sky130_fd_pr__nfet_01v8 l=0.5 w=5
XM2 N4 I_OUTB2 N1 GND sky130_fd_pr__nfet_01v8 l=0.5 w=5
XM3 SQ_OUTB I_OUT N3 GND sky130_fd_pr__nfet_01v8 l=0.5 w=5
XM4 SQ_OUT I_OUTB N3 GND sky130_fd_pr__nfet_01v8 l=0.5 w=5
XM5 SQ_OUTB I_OUTB N4 GND sky130_fd_pr__nfet_01v8 l=0.5 w=5
XM6 SQ_OUT I_OUT N4 GND sky130_fd_pr__nfet_01v8 l=0.5 w=5
XM7 N5 Q_OUT2 N2 GND sky130_fd_pr__nfet_01v8 l=0.5 w=5
XM8 N6 Q_OUTB2 N2 GND sky130_fd_pr__nfet_01v8 l=0.5 w=5
XM9 SQ_OUTB Q_OUT N5 GND sky130_fd_pr__nfet_01v8 l=0.5 w=5
XM10 SQ_OUT Q_OUTB N5 GND sky130_fd_pr__nfet_01v8 l=0.5 w=5
XM11 SQ_OUTB Q_OUTB N6 GND sky130_fd_pr__nfet_01v8 l=0.5 w=5
XM12 SQ_OUT Q_OUT N6 GND sky130_fd_pr__nfet_01v8 l=0.5 w=5

.control
set filetype=ascii

op
let vdd_current = abs(i(VVDD))
let power_dc = vdd_current * 1.8
print power_dc

print all

let vout_dc = v(SQ_OUT)
print vout_dc
let vout_dc = v(N2)
print vout_dc
quit
.endc

.end
