* Testcase 000685 — Full Analysis (sky130 tt corner)
* SKY130 model header — replaces the ideal level-1 .model cards
* Ships with the demo; the paths point at the local sky130 PDK checkout.
* NOTE: libs.tech/ngspice/all.spice sets ".option scale=1.0u", so every
* instance L/W below is written in microns WITHOUT a "u" suffix.
.param mc_mm_switch=0
.param mc_pr_switch=0
.include /home/idies/workspace/Temporary/xyu1/scratch/skywater-pdk-libs-sky130_fd_pr/models/corners/tt.spice
.include /home/idies/workspace/Temporary/xyu1/scratch/skywater-pdk-libs-sky130_fd_pr/models/r+c/res_typical__cap_typical.spice
.include /home/idies/workspace/Temporary/xyu1/scratch/skywater-pdk-libs-sky130_fd_pr/models/r+c/res_typical__cap_typical__lin.spice
.include /home/idies/workspace/Temporary/xyu1/scratch/skywater-pdk-libs-sky130_fd_pr/models/corners/tt/specialized_cells.spice
.model DIDEAL D   is=1e-14 n=1
.options reltol=1e-3 itl1=500 itl2=100

* Sources
VVDD VDD 0 1.8
VVBIAS VBIAS 0 0.75
VVCTRL VCTRL 0 0.9
VVIN VIN 0 DC 0.9 AC 1 SIN(0.9 0.1 1MEG 0 0)

* Circuit
I1 N4 GND 1u
I2 N5 GND 1u
XQ1 N2 VBIAS N1 0 sky130_fd_pr__npn_05v5_W1p00L1p00
XQ2 N0 VBIAS N6 0 sky130_fd_pr__npn_05v5_W1p00L1p00
RE N4 N5 10k
XQ3 N1 VIP N5 0 sky130_fd_pr__npn_05v5_W1p00L1p00
XQ4 VDD VCTRL N1 0 sky130_fd_pr__npn_05v5_W1p00L1p00
CL N0 N2 1p
XQ5 VDD VCTRL N6 0 sky130_fd_pr__npn_05v5_W1p00L1p00
RL2 N0 VDD 10k
XQ6 N6 VIN N4 0 sky130_fd_pr__npn_05v5_W1p00L1p00
RL1 N2 VDD 10k

.control
set filetype=ascii

op
let power_dc = abs(i(VVDD)) * 1.8
print power_dc

ac dec 100 1 10g
let vout_mag = vm(N4)
let gain_db = db(vout_mag)
let dc_gain_db = gain_db[0]
print dc_gain_db

if dc_gain_db > 0
    meas ac ugbw WHEN gain_db=0 CROSS=1
    print ugbw
end

quit
.endc

.end
