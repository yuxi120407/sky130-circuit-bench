* Testcase 000193 — Full Analysis (sky130 tt corner)
* SKY130 model header — replaces the ideal level-1 .model cards
* Ships with the demo; the paths point at the local sky130 PDK checkout.
* NOTE: libs.tech/ngspice/all.spice sets ".option scale=1.0u", so every
* instance L/W below is written in microns WITHOUT a "u" suffix.
.param mc_mm_switch=0
.param mc_pr_switch=0
.include /home/idies/workspace/Temporary/xyu1/scratch/skywater-pdk-libs-sky130_fd_pr/models/corners/tt.spice
.include /home/idies/workspace/Temporary/xyu1/scratch/skywater-pdk-libs-sky130_fd_pr/models/r+c/res_typical__cap_typical.spice
.include /home/idies/workspace/Temporary/xyu1/scratch/skywater-pdk-libs-sky130_fd_pr/models/r+c/res_typical__cap_typical__lin.spice
.include /home/idies/workspace/Temporary/xyu1/scratch/skywater-pdk-libs-sky130_fd_pr/models/corners/tt/specialized_cells.spice
.model DIDEAL D   is=1e-14 n=1
.options reltol=1e-3 itl1=500 itl2=100

* Sources
VVDD VDD 0 1.8
VVIN1_PLUS VIN1_PLUS 0 DC 0.9 AC 1 SIN(0.9 0.1 1MEG 0 0)
VVIN1_MINUS VIN1_MINUS 0 DC 0.9 AC 1 SIN(0.9 0.1 1MEG 0 0)
VVCONT VCONT 0 0.9
VLABEL_NET_2 LABEL_NET_2 0 0.9
VVIN2_PLUS VIN2_PLUS 0 DC 0.9 AC 1 SIN(0.9 0.1 1MEG 0 0)
VVIN2_MINUS VIN2_MINUS 0 DC 0.9 AC 1 SIN(0.9 0.1 1MEG 0 0)

* Circuit
XM1 N0 VIN1_PLUS GND GND sky130_fd_pr__nfet_01v8 l=0.5 w=5
XM2 N2 VIN1_MINUS GND GND sky130_fd_pr__nfet_01v8 l=0.5 w=5
XM8 N2 VCONT N1 GND sky130_fd_pr__nfet_01v8 l=0.5 w=5
XM7 N0 VCONT N4 GND sky130_fd_pr__nfet_01v8 l=0.5 w=5
XM5 N0 LABEL_NET_2 VDD VDD sky130_fd_pr__pfet_01v8 l=0.5 w=5
C2 N1 GND 1p
XM6 N2 N0 VDD VDD sky130_fd_pr__pfet_01v8 l=0.5 w=5
XM4 N2 VIN2_PLUS VDD VDD sky130_fd_pr__pfet_01v8 l=0.5 w=5
XM3 N0 VIN2_MINUS VDD VDD sky130_fd_pr__pfet_01v8 l=0.5 w=5
C1 N4 GND 1p

.control
set filetype=ascii

op
let vdd_current = abs(i(VVDD))
let power_dc = vdd_current * 1.8
print power_dc

ac dec 100 1 10g
let vout_mag = vm(N1)
let gain_db = db(vout_mag)
let dc_gain_db = gain_db[0]
print dc_gain_db

if dc_gain_db > 0
    meas ac ugbw WHEN gain_db=0 CROSS=1
end

quit
.endc

.end
