* Testcase 001202 — Full Analysis (sky130 tt corner)
* SKY130 model header — replaces the ideal level-1 .model cards
* Ships with the demo; the paths point at the local sky130 PDK checkout.
* NOTE: libs.tech/ngspice/all.spice sets ".option scale=1.0u", so every
* instance L/W below is written in microns WITHOUT a "u" suffix.
.param mc_mm_switch=0
.param mc_pr_switch=0
.include /home/idies/workspace/Temporary/xyu1/scratch/skywater-pdk-libs-sky130_fd_pr/models/corners/tt.spice
.include /home/idies/workspace/Temporary/xyu1/scratch/skywater-pdk-libs-sky130_fd_pr/models/r+c/res_typical__cap_typical.spice
.include /home/idies/workspace/Temporary/xyu1/scratch/skywater-pdk-libs-sky130_fd_pr/models/r+c/res_typical__cap_typical__lin.spice
.include /home/idies/workspace/Temporary/xyu1/scratch/skywater-pdk-libs-sky130_fd_pr/models/corners/tt/specialized_cells.spice
.model DIDEAL D   is=1e-14 n=1
.options reltol=1e-3 itl1=500 itl2=100

* Sources
VVDD VDD 0 1.8

* Circuit
XM71 VD2 VD2 VD2 GND sky130_fd_pr__nfet_01v8 l=0.5 w=5
XM82 N7 N7 N4 GND sky130_fd_pr__nfet_01v8 l=0.5 w=5
XM7 N1 N1 GND GND sky130_fd_pr__nfet_01v8 l=0.5 w=5
XM4 N1 VD2 N6 VDD sky130_fd_pr__pfet_01v8 l=0.5 w=5
XM85 N7 N7 VD2 GND sky130_fd_pr__nfet_01v8 l=0.5 w=5
XM83 N7 N7 N2 VDD sky130_fd_pr__pfet_01v8 l=0.5 w=5
XM27 VD2 VD2 VDD VDD sky130_fd_pr__pfet_01v8 l=0.5 w=5
XM26 VD2 VD2 VDD VDD sky130_fd_pr__pfet_01v8 l=0.5 w=5
XM84 N2 N2 VDD VDD sky130_fd_pr__pfet_01v8 l=0.5 w=5
D2 VD2 GND DIDEAL
XM23 N6 VD2 VDD VDD sky130_fd_pr__pfet_01v8 l=0.5 w=5
XM24 VD2 VD2 VDD VDD sky130_fd_pr__pfet_01v8 l=0.5 w=5
XM2 GND VD2 N3 VDD sky130_fd_pr__pfet_01v8 l=0.5 w=5
XM5 GND VOUT N1 GND sky130_fd_pr__nfet_01v8 l=0.5 w=5
XM3 GND VD1 N6 VDD sky130_fd_pr__pfet_01v8 l=0.5 w=5
XM72 VD2 VD2 VD1 GND sky130_fd_pr__nfet_01v8 l=0.5 w=5
XM81 N4 N4 GND GND sky130_fd_pr__nfet_01v8 l=0.5 w=5
XM22 N3 VD2 VDD VDD sky130_fd_pr__pfet_01v8 l=0.5 w=5
XM1 VOUT VOUT N3 VDD sky130_fd_pr__pfet_01v8 l=0.5 w=5
D1 VD1 GND DIDEAL

.control
set filetype=ascii

op
let vdd_current = abs(i(VVDD))
let power_dc = vdd_current * 1.8
let vout_dc = v(VOUT)
print power_dc vout_dc

quit
.endc

.end
