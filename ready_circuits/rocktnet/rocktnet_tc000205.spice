* Testcase 000205 — Full Analysis (sky130 tt corner)
* SKY130 model header — replaces the ideal level-1 .model cards
* Ships with the demo; the paths point at the local sky130 PDK checkout.
* NOTE: libs.tech/ngspice/all.spice sets ".option scale=1.0u", so every
* instance L/W below is written in microns WITHOUT a "u" suffix.
.param mc_mm_switch=0
.param mc_pr_switch=0
.include /home/idies/workspace/Temporary/xyu1/scratch/skywater-pdk-libs-sky130_fd_pr/models/corners/tt.spice
.include /home/idies/workspace/Temporary/xyu1/scratch/skywater-pdk-libs-sky130_fd_pr/models/r+c/res_typical__cap_typical.spice
.include /home/idies/workspace/Temporary/xyu1/scratch/skywater-pdk-libs-sky130_fd_pr/models/r+c/res_typical__cap_typical__lin.spice
.include /home/idies/workspace/Temporary/xyu1/scratch/skywater-pdk-libs-sky130_fd_pr/models/corners/tt/specialized_cells.spice
.model DIDEAL D   is=1e-14 n=1
.options reltol=1e-3 itl1=500 itl2=100

* Sources
VIN IN 0 DC 0.9 AC 1 SIN(0.9 0.1 1MEG 0 0)
VINQ INQ 0 DC 0.9 AC 1 SIN(0.9 0.1 1MEG 0 0)

* Circuit
R24 IN GND 50
R19 INQ GND 50
XQ21 GND IN E_Q21 0 sky130_fd_pr__npn_05v5_W1p00L1p00
R14 E_Q21 VEE 10k
XQ25 GND INQ E_Q25 0 sky130_fd_pr__npn_05v5_W1p00L1p00
R16 E_Q25 VEE 10k
XQ12 GND E_Q21 E_Q12 0 sky130_fd_pr__npn_05v5_W1p00L1p00
R15 E_Q12 VEE 10k
XQ2 GND E_Q25 E_Q2 0 sky130_fd_pr__npn_05v5_W1p00L1p00
R23 E_Q2 VEE 10k
XQ8 TAS1_C1 E_Q12 E_Q8 0 sky130_fd_pr__npn_05v5_W1p00L1p00
XQ15 TAS1_C2 E_Q2 E_Q15 0 sky130_fd_pr__npn_05v5_W1p00L1p00
R3 E_Q8 TAS1_E 10k
R4 E_Q15 TAS1_E 10k
I1 TAS1_E VEE 1u
R6 GND TAS1_C1 10k
R5 GND TAS1_C2 10k
XQ1 TAS1_C2 TAS1_C1 TIS1_E 0 sky130_fd_pr__npn_05v5_W1p00L1p00
XQ4 TAS1_C1 TAS1_C2 TIS1_E 0 sky130_fd_pr__npn_05v5_W1p00L1p00
I2 TIS1_E VEE 1u
XQ20 GND TAS1_C1 E_Q20 0 sky130_fd_pr__npn_05v5_W1p00L1p00
R2 E_Q20 VEE 10k
XQ24 GND TAS1_C2 E_Q24 0 sky130_fd_pr__npn_05v5_W1p00L1p00
R1 E_Q24 VEE 10k
XQ9 GND E_Q20 E_Q9 0 sky130_fd_pr__npn_05v5_W1p00L1p00
R13 E_Q9 VEE 10k
XQ16 GND E_Q24 E_Q16 0 sky130_fd_pr__npn_05v5_W1p00L1p00
R17 E_Q16 VEE 10k
XQ3 TAS2_C1 E_Q9 E_Q3 0 sky130_fd_pr__npn_05v5_W1p00L1p00
XQ11 TAS2_C2 E_Q16 E_Q11 0 sky130_fd_pr__npn_05v5_W1p00L1p00
R7 E_Q3 TAS2_E 10k
R8 E_Q11 TAS2_E 10k
I3 TAS2_E VEE 1u
R11 GND TAS2_C1 10k
R10 GND TAS2_C2 10k
XQ23 TAS2_C2 TAS2_C1 TIS2_E 0 sky130_fd_pr__npn_05v5_W1p00L1p00
XQ19 TAS2_C1 TAS2_C2 TIS2_E 0 sky130_fd_pr__npn_05v5_W1p00L1p00
I4 TIS2_E VEE 1u
XQ26 GND TAS2_C1 E_Q26 0 sky130_fd_pr__npn_05v5_W1p00L1p00
R18 E_Q26 VEE 10k
XQ14 GND TAS2_C2 E_Q14 0 sky130_fd_pr__npn_05v5_W1p00L1p00
R20 E_Q14 VEE 10k
XQ18 GND E_Q26 E_Q18 0 sky130_fd_pr__npn_05v5_W1p00L1p00
R21 E_Q18 VEE 10k
XQ6 GND E_Q14 E_Q6 0 sky130_fd_pr__npn_05v5_W1p00L1p00
R28 E_Q6 VEE 10k
XQ5 OUTQ E_Q18 E_Q5 0 sky130_fd_pr__npn_05v5_W1p00L1p00
XQ7 OUT E_Q6 E_Q7 0 sky130_fd_pr__npn_05v5_W1p00L1p00
R26 E_Q5 TAS3_E 10k
R27 E_Q7 TAS3_E 10k
I5 TAS3_E VEE 1u
R22 GND OUTQ 50
R29 GND OUT 50

.control
set filetype=ascii

op
let vdd_current = abs(i(VVDD))
let power_dc = vdd_current * 1.8
print power_dc

ac dec 100 1 10g
let vout_mag = vm(OUT)
let gain_db = db(vout_mag)
let dc_gain_db = gain_db[0]
print dc_gain_db

if dc_gain_db > 0
    meas ac ugbw WHEN gain_db=0 CROSS=1
end

quit
.endc

.end
