* Testcase 000836 — Full Analysis (sky130 tt corner)
* SKY130 model header — replaces the ideal level-1 .model cards
* Ships with the demo; the paths point at the local sky130 PDK checkout.
* NOTE: libs.tech/ngspice/all.spice sets ".option scale=1.0u", so every
* instance L/W below is written in microns WITHOUT a "u" suffix.
.param mc_mm_switch=0
.param mc_pr_switch=0
.include /home/idies/workspace/Temporary/xyu1/scratch/skywater-pdk-libs-sky130_fd_pr/models/corners/tt.spice
.include /home/idies/workspace/Temporary/xyu1/scratch/skywater-pdk-libs-sky130_fd_pr/models/r+c/res_typical__cap_typical.spice
.include /home/idies/workspace/Temporary/xyu1/scratch/skywater-pdk-libs-sky130_fd_pr/models/r+c/res_typical__cap_typical__lin.spice
.include /home/idies/workspace/Temporary/xyu1/scratch/skywater-pdk-libs-sky130_fd_pr/models/corners/tt/specialized_cells.spice
.model DIDEAL D   is=1e-14 n=1
.options reltol=1e-3 itl1=500 itl2=100

* Sources
VVB3 VB3 0 DC 0.75 AC 0.5

* Circuit
LE1 N4 N9 10n
LE2 N4 N6 10n
IE3 N4 GND 1u
L3 N5 VCC 10n
CO N5 N10 1p
L4 VCC N10 10n
L5 LOIN GND 10n
XQ23 N10 N2 N0 0 sky130_fd_pr__npn_05v5_W1p00L1p00
L6 VCC GND 10n
XQ25 N10 N3 N1 0 sky130_fd_pr__npn_05v5_W1p00L1p00
RB3_1 N2 VB3 10k
RB3_2 N3 VB3 10k
XQ26 N5 N2 N1 0 sky130_fd_pr__npn_05v5_W1p00L1p00
XQ21 N0 IFIN_PLUS N9 0 sky130_fd_pr__npn_05v5_W1p00L1p00
L7 N2 N3 10n
XQ22 N1 IFIN_MINUS N6 0 sky130_fd_pr__npn_05v5_W1p00L1p00
XQ24 N5 N3 N0 0 sky130_fd_pr__npn_05v5_W1p00L1p00

.control
set filetype=ascii

op
let power_dc = abs(i(VVB3)) * 1.8
print power_dc
let dc_voltage = v(LOIN)
print dc_voltage

quit
.endc

.end
