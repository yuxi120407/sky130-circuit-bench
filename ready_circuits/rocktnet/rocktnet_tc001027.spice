* Testcase 001027 — Full Analysis (sky130 tt corner)
* SKY130 model header — replaces the ideal level-1 .model cards
* Ships with the demo; the paths point at the local sky130 PDK checkout.
* NOTE: libs.tech/ngspice/all.spice sets ".option scale=1.0u", so every
* instance L/W below is written in microns WITHOUT a "u" suffix.
.param mc_mm_switch=0
.param mc_pr_switch=0
.include /home/idies/workspace/Temporary/xyu1/scratch/skywater-pdk-libs-sky130_fd_pr/models/corners/tt.spice
.include /home/idies/workspace/Temporary/xyu1/scratch/skywater-pdk-libs-sky130_fd_pr/models/r+c/res_typical__cap_typical.spice
.include /home/idies/workspace/Temporary/xyu1/scratch/skywater-pdk-libs-sky130_fd_pr/models/r+c/res_typical__cap_typical__lin.spice
.include /home/idies/workspace/Temporary/xyu1/scratch/skywater-pdk-libs-sky130_fd_pr/models/corners/tt/specialized_cells.spice
.model DIDEAL D   is=1e-14 n=1
.options reltol=1e-3 itl1=500 itl2=100

* Sources
VVDD VDD 0 1.8
VIN IN 0 DC 0.9 AC 1 SIN(0.9 0.1 1MEG 0 0)

* Circuit
I1 VDD N0 1u
XM1 N11 N5 N4 GND sky130_fd_pr__nfet_01v8 l=0.5 w=5
XM2 N0 N2 GND GND sky130_fd_pr__nfet_01v8 l=0.5 w=5
XM3 N13 N13 VDD VDD sky130_fd_pr__pfet_01v8 l=0.5 w=5
XM4 N8 N8 N6 VDD sky130_fd_pr__pfet_01v8 l=0.5 w=5
XM5 N8 IN N7 GND sky130_fd_pr__nfet_01v8 l=0.5 w=5
XM6 H_BAR N12 GND GND sky130_fd_pr__nfet_01v8 l=0.5 w=5
XM7 N7 N3 GND GND sky130_fd_pr__nfet_01v8 l=0.5 w=5
XM8 N5 N6 VDD VDD sky130_fd_pr__pfet_01v8 l=0.5 w=5
XM9 N11 N11 VDD VDD sky130_fd_pr__pfet_01v8 l=0.5 w=5
XM10 H N13 VDD VDD sky130_fd_pr__pfet_01v8 l=0.5 w=5
XM11 N6 VHIGH N7 GND sky130_fd_pr__nfet_01v8 l=0.5 w=5
XM12 N13 N0 N4 GND sky130_fd_pr__nfet_01v8 l=0.5 w=5
XM13 N5 N10 GND GND sky130_fd_pr__nfet_01v8 l=0.5 w=5
XM14 H_BAR N11 VDD VDD sky130_fd_pr__pfet_01v8 l=0.5 w=5
XM15 N0 N2 GND GND sky130_fd_pr__nfet_01v8 l=0.5 w=5
XM16 H N0 GND GND sky130_fd_pr__nfet_01v8 l=0.5 w=5
XM17 N0 N8 VDD VDD sky130_fd_pr__pfet_01v8 l=0.5 w=5
XM18 N6 N6 VDD VDD sky130_fd_pr__pfet_01v8 l=0.5 w=5
XM19 N4 N12 GND GND sky130_fd_pr__nfet_01v8 l=0.5 w=5

.control
set filetype=ascii

op
let power_dc = abs(i(VVDD)) * 1.8
print power_dc

ac dec 100 1 10g
let vout_mag = vm(H_BAR)
let gain_db = db(vout_mag)
let dc_gain_db = gain_db[0]
print dc_gain_db

if dc_gain_db > 0
    meas ac ugbw WHEN gain_db=0 CROSS=1
    print ugbw
end

quit
.endc

.end
