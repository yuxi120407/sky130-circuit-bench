* Testcase 000229 — Full Analysis (sky130 tt corner)
* SKY130 model header — replaces the ideal level-1 .model cards
* Ships with the demo; the paths point at the local sky130 PDK checkout.
* NOTE: libs.tech/ngspice/all.spice sets ".option scale=1.0u", so every
* instance L/W below is written in microns WITHOUT a "u" suffix.
.param mc_mm_switch=0
.param mc_pr_switch=0
.include /home/idies/workspace/Temporary/xyu1/scratch/skywater-pdk-libs-sky130_fd_pr/models/corners/tt.spice
.include /home/idies/workspace/Temporary/xyu1/scratch/skywater-pdk-libs-sky130_fd_pr/models/r+c/res_typical__cap_typical.spice
.include /home/idies/workspace/Temporary/xyu1/scratch/skywater-pdk-libs-sky130_fd_pr/models/r+c/res_typical__cap_typical__lin.spice
.include /home/idies/workspace/Temporary/xyu1/scratch/skywater-pdk-libs-sky130_fd_pr/models/corners/tt/specialized_cells.spice
.model DIDEAL D   is=1e-14 n=1
.options reltol=1e-3 itl1=500 itl2=100

* Sources
VVDD VDD 0 1.8
VVCTRL VCTRL 0 0.9

* Circuit
XM1 GND GND N1 VDD sky130_fd_pr__pfet_01v8 l=0.5 w=5
XM2 GND VCTRL N1 VDD sky130_fd_pr__pfet_01v8 l=0.5 w=5
XM3 N1 GND VCO_SUPPLY VDD sky130_fd_pr__pfet_01v8 l=0.5 w=5
XM4 N2 GND N0 VDD sky130_fd_pr__pfet_01v8 l=0.5 w=5
XM5 GND N2 GND GND sky130_fd_pr__nfet_01v8 l=0.5 w=5
XM6 GND GND N0 VDD sky130_fd_pr__pfet_01v8 l=0.5 w=5
XM7 N0 GND ADAPTIVE_SUPPLY VDD sky130_fd_pr__pfet_01v8 l=0.5 w=5
XM8 GND VDD N0 VDD sky130_fd_pr__pfet_01v8 l=0.5 w=5

.control
set filetype=ascii

op
let vdd_current = abs(i(VVDD))
let power_dc = vdd_current * 1.8
print power_dc

print all

let vout_dc = v(N0)
print vout_dc
let vout_dc = v(N2)
print vout_dc
quit
.endc

.end
