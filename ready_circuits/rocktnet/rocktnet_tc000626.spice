* Testcase 000626 — Full Analysis (sky130 tt corner)
* SKY130 model header — replaces the ideal level-1 .model cards
* Ships with the demo; the paths point at the local sky130 PDK checkout.
* NOTE: libs.tech/ngspice/all.spice sets ".option scale=1.0u", so every
* instance L/W below is written in microns WITHOUT a "u" suffix.
.param mc_mm_switch=0
.param mc_pr_switch=0
.include /home/idies/workspace/Temporary/xyu1/scratch/skywater-pdk-libs-sky130_fd_pr/models/corners/tt.spice
.include /home/idies/workspace/Temporary/xyu1/scratch/skywater-pdk-libs-sky130_fd_pr/models/r+c/res_typical__cap_typical.spice
.include /home/idies/workspace/Temporary/xyu1/scratch/skywater-pdk-libs-sky130_fd_pr/models/r+c/res_typical__cap_typical__lin.spice
.include /home/idies/workspace/Temporary/xyu1/scratch/skywater-pdk-libs-sky130_fd_pr/models/corners/tt/specialized_cells.spice
.model DIDEAL D   is=1e-14 n=1
.options reltol=1e-3 itl1=500 itl2=100

* Sources
VVDD VDD 0 1.8

* Circuit
XQ2 COLL_Q1 RF_P EMIT_I 0 sky130_fd_pr__npn_05v5_W1p00L1p00
XQ10 COLL_Q2 RF_N EMIT_I 0 sky130_fd_pr__npn_05v5_W1p00L1p00
XQ1 I_CH_P LO_I_P COLL_Q1 0 sky130_fd_pr__npn_05v5_W1p00L1p00
XQ6 I_CH_N LO_I_N COLL_Q1 0 sky130_fd_pr__npn_05v5_W1p00L1p00
XQ7 I_CH_P LO_I_N COLL_Q2 0 sky130_fd_pr__npn_05v5_W1p00L1p00
XQ12 I_CH_N LO_I_P COLL_Q2 0 sky130_fd_pr__npn_05v5_W1p00L1p00
XQ4 COLL_Q7 RF_P EMIT_Q 0 sky130_fd_pr__npn_05v5_W1p00L1p00
XQ3 COLL_Q8 RF_N EMIT_Q 0 sky130_fd_pr__npn_05v5_W1p00L1p00
XQ11 Q_CH_P LO_Q_P COLL_Q7 0 sky130_fd_pr__npn_05v5_W1p00L1p00
XQ9 Q_CH_N LO_Q_N COLL_Q7 0 sky130_fd_pr__npn_05v5_W1p00L1p00
XQ5 Q_CH_P LO_Q_N COLL_Q8 0 sky130_fd_pr__npn_05v5_W1p00L1p00
XQ8 Q_CH_N LO_Q_P COLL_Q8 0 sky130_fd_pr__npn_05v5_W1p00L1p00
C1 I_CH_P VDD 1p
C2 VDD Q_CH_P 1p
C3 I_CH_N VDD 1p
C4 Q_CH_N VDD 1p
R1 EMIT_I GND 10k
R2 EMIT_Q GND 10k
R3 VDD Q_CH_P 10k
R4 Q_CH_N VDD 10k
R5 I_CH_P VDD 10k
R6 I_CH_N VDD 10k

.control
set filetype=ascii

op
let vdd_current = abs(i(VVDD))
let power_dc = vdd_current * 1.8
print power_dc

ac dec 100 1 10g
let vout_mag = vm(EMIT_I)
let gain_db = db(vout_mag)
let dc_gain_db = gain_db[0]
print dc_gain_db

if dc_gain_db > 0
    meas ac ugbw WHEN gain_db=0 CROSS=1
end

quit
.endc

.end
