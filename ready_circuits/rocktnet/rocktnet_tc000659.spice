* Testcase 000659 — Full Analysis (sky130 tt corner)
* SKY130 model header — replaces the ideal level-1 .model cards
* Ships with the demo; the paths point at the local sky130 PDK checkout.
* NOTE: libs.tech/ngspice/all.spice sets ".option scale=1.0u", so every
* instance L/W below is written in microns WITHOUT a "u" suffix.
.param mc_mm_switch=0
.param mc_pr_switch=0
.include /home/idies/workspace/Temporary/xyu1/scratch/skywater-pdk-libs-sky130_fd_pr/models/corners/tt.spice
.include /home/idies/workspace/Temporary/xyu1/scratch/skywater-pdk-libs-sky130_fd_pr/models/r+c/res_typical__cap_typical.spice
.include /home/idies/workspace/Temporary/xyu1/scratch/skywater-pdk-libs-sky130_fd_pr/models/r+c/res_typical__cap_typical__lin.spice
.include /home/idies/workspace/Temporary/xyu1/scratch/skywater-pdk-libs-sky130_fd_pr/models/corners/tt/specialized_cells.spice
.model DIDEAL D   is=1e-14 n=1
.options reltol=1e-3 itl1=500 itl2=100

* Sources
VVDD VDD 0 1.8
VINM INM 0 DC 0.9 AC 1 SIN(0.9 0.1 1MEG 0 0)
VINP INP 0 DC 0.9 AC 1 SIN(0.9 0.1 1MEG 0 0)
VLABEL_NET_3 LABEL_NET_3 0 0.9
VLABEL_NET_4 LABEL_NET_4 0 0.9

* Circuit
XM1 OUTP OUTM N1 GND sky130_fd_pr__nfet_01v8 l=0.5 w=5
R1 VDD OUTM 10k
XM2 OUTP INM N2 GND sky130_fd_pr__nfet_01v8 l=0.5 w=5
R2 VDD OUTP 10k
XM3 OUTM OUTP N1 GND sky130_fd_pr__nfet_01v8 l=0.5 w=5
XM4 OUTM INP N2 GND sky130_fd_pr__nfet_01v8 l=0.5 w=5
XM5 N1 CLKB N0 GND sky130_fd_pr__nfet_01v8 l=0.5 w=5
XM6 N3 LABEL_NET_3 GND GND sky130_fd_pr__nfet_01v8 l=0.5 w=5
XM7 N0 LABEL_NET_4 N3 GND sky130_fd_pr__nfet_01v8 l=0.5 w=5
XM8 N2 CLK N0 GND sky130_fd_pr__nfet_01v8 l=0.5 w=5

.control
set filetype=ascii

op
let vdd_current = abs(i(VVDD))
let power_dc = vdd_current * 1.8
print power_dc

ac dec 100 1 10g
let vout_mag = vm(OUTP)
let gain_db = db(vout_mag)
let dc_gain_db = gain_db[0]
print dc_gain_db

if dc_gain_db > 0
    meas ac ugbw WHEN gain_db=0 CROSS=1
end

quit
.endc

.end
