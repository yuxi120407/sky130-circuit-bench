* Testcase 001040 — Full Analysis (sky130 tt corner)
* SKY130 model header — replaces the ideal level-1 .model cards
* Ships with the demo; the paths point at the local sky130 PDK checkout.
* NOTE: libs.tech/ngspice/all.spice sets ".option scale=1.0u", so every
* instance L/W below is written in microns WITHOUT a "u" suffix.
.param mc_mm_switch=0
.param mc_pr_switch=0
.include /home/idies/workspace/Temporary/xyu1/scratch/skywater-pdk-libs-sky130_fd_pr/models/corners/tt.spice
.include /home/idies/workspace/Temporary/xyu1/scratch/skywater-pdk-libs-sky130_fd_pr/models/r+c/res_typical__cap_typical.spice
.include /home/idies/workspace/Temporary/xyu1/scratch/skywater-pdk-libs-sky130_fd_pr/models/r+c/res_typical__cap_typical__lin.spice
.include /home/idies/workspace/Temporary/xyu1/scratch/skywater-pdk-libs-sky130_fd_pr/models/corners/tt/specialized_cells.spice
.model DIDEAL D   is=1e-14 n=1
.options reltol=1e-3 itl1=500 itl2=100

* Sources
VVDD VDD 0 1.8

* Circuit
XM6 VOUTP VLOIP ILFIP GND sky130_fd_pr__nfet_01v8 l=0.5 w=5
XM7 VOUTN VLOIN ILFIP GND sky130_fd_pr__nfet_01v8 l=0.5 w=5
XM3 VOUTN VLOIP ILFIN GND sky130_fd_pr__nfet_01v8 l=0.5 w=5
XM8 VOUTP VLOIN ILFIN GND sky130_fd_pr__nfet_01v8 l=0.5 w=5
XM1 VOUTP VLOQP ILFQP GND sky130_fd_pr__nfet_01v8 l=0.5 w=5
XM5 VOUTN VLOQN ILFQP GND sky130_fd_pr__nfet_01v8 l=0.5 w=5
XM2 VOUTP VLOQN ILFQN GND sky130_fd_pr__nfet_01v8 l=0.5 w=5
XM4 VOUTN VLOQP ILFQN GND sky130_fd_pr__nfet_01v8 l=0.5 w=5
RL1 VDD VOUTP 10k
RL2 VDD VOUTN 10k
ILFIP ILFIP GND 1u
C2 ILFIP GND 1p
ILFIN ILFIN GND 1u
C ILFIN GND 1p
ILFQP ILFQP GND 1u
C3 ILFQP GND 1p
ILFQN ILFQN GND 1u
C1 ILFQN GND 1p

.control
set filetype=ascii

op
let vdd_current = abs(i(VVDD))
let power_dc = vdd_current * 1.8
print power_dc

ac dec 100 1 10g
let vout_mag = vm(ILFIP)
let gain_db = db(vout_mag)
let dc_gain_db = gain_db[0]
print dc_gain_db

if dc_gain_db > 0
    meas ac ugbw WHEN gain_db=0 CROSS=1
end

quit
.endc

.end
