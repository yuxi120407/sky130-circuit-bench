* Testcase 000662 — Full Analysis (sky130 tt corner)
* SKY130 model header — replaces the ideal level-1 .model cards
* Ships with the demo; the paths point at the local sky130 PDK checkout.
* NOTE: libs.tech/ngspice/all.spice sets ".option scale=1.0u", so every
* instance L/W below is written in microns WITHOUT a "u" suffix.
.param mc_mm_switch=0
.param mc_pr_switch=0
.include /home/idies/workspace/Temporary/xyu1/scratch/skywater-pdk-libs-sky130_fd_pr/models/corners/tt.spice
.include /home/idies/workspace/Temporary/xyu1/scratch/skywater-pdk-libs-sky130_fd_pr/models/r+c/res_typical__cap_typical.spice
.include /home/idies/workspace/Temporary/xyu1/scratch/skywater-pdk-libs-sky130_fd_pr/models/r+c/res_typical__cap_typical__lin.spice
.include /home/idies/workspace/Temporary/xyu1/scratch/skywater-pdk-libs-sky130_fd_pr/models/corners/tt/specialized_cells.spice
.model DIDEAL D   is=1e-14 n=1
.options reltol=1e-3 itl1=500 itl2=100

* Sources
VVDD VDD 0 1.8

* Circuit
CIN_PLUS NIN_PLUS N1_PLUS 1p
CIN_MINUS NIN_MINUS N1_MINUS 1p
R1_2 N1_PLUS N2_MINUS 10k
R1 N1_MINUS N2_PLUS 10k
R1_3 N1_PLUS N4 10k
R1_4 N1_MINUS N4 10k
R3 N2_PLUS VDD 10k
R3_2 N2_MINUS VDD 10k
XT1 N2_PLUS N1_PLUS N3_PLUS 0 sky130_fd_pr__npn_05v5_W1p00L1p00
XT1_2 N2_MINUS N1_MINUS N3_MINUS 0 sky130_fd_pr__npn_05v5_W1p00L1p00
R2 N3_PLUS GND 10k
R2_2 N3_MINUS GND 10k
C2 N3_PLUS N3_MINUS 1p
V1 N4 GND DC 0 AC 0.5

.control
set filetype=ascii

op
let vdd_current = abs(i(VVDD))
let power_dc = vdd_current * 1.8
print power_dc

ac dec 100 1 10g
let vout_mag = vm(N3_PLUS)
let gain_db = db(vout_mag)
let dc_gain_db = gain_db[0]
print dc_gain_db

if dc_gain_db > 0
    meas ac ugbw WHEN gain_db=0 CROSS=1
end

quit
.endc

.end
