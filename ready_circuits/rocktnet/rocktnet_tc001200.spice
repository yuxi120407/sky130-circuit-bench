* Testcase 001200 — Full Analysis (sky130 tt corner)
* SKY130 model header — replaces the ideal level-1 .model cards
* Ships with the demo; the paths point at the local sky130 PDK checkout.
* NOTE: libs.tech/ngspice/all.spice sets ".option scale=1.0u", so every
* instance L/W below is written in microns WITHOUT a "u" suffix.
.param mc_mm_switch=0
.param mc_pr_switch=0
.include /home/idies/workspace/Temporary/xyu1/scratch/skywater-pdk-libs-sky130_fd_pr/models/corners/tt.spice
.include /home/idies/workspace/Temporary/xyu1/scratch/skywater-pdk-libs-sky130_fd_pr/models/r+c/res_typical__cap_typical.spice
.include /home/idies/workspace/Temporary/xyu1/scratch/skywater-pdk-libs-sky130_fd_pr/models/r+c/res_typical__cap_typical__lin.spice
.include /home/idies/workspace/Temporary/xyu1/scratch/skywater-pdk-libs-sky130_fd_pr/models/corners/tt/specialized_cells.spice
.model DIDEAL D   is=1e-14 n=1
.options reltol=1e-3 itl1=500 itl2=100

* Sources
VVDD VDD 0 1.8

* Circuit
IT VDD N3 1u
ID VDD GND 1u
IGIT VDD N1 1u
I10D VDD VD2 1u
XM1 VOUT VOUT N1 VDD sky130_fd_pr__pfet_01v8 l=0.5 w=5
XM7 VD2 VD2 GND GND sky130_fd_pr__nfet_01v8 l=0.5 w=5
D1 VD2 GND DIDEAL
XM2 GND VD2 N1 VDD sky130_fd_pr__pfet_01v8 l=0.5 w=5
XM4 VD2 VD2 N3 VDD sky130_fd_pr__pfet_01v8 l=0.5 w=5
XM3 GND GND N3 VDD sky130_fd_pr__pfet_01v8 l=0.5 w=5
XM5 VOUT VD2 GND GND sky130_fd_pr__nfet_01v8 l=0.5 w=5

.control
set filetype=ascii

op
let vdd_current = abs(i(VVDD))
let power_dc = vdd_current * 1.8
let vout_dc = v(VOUT)
print power_dc vout_dc

quit
.endc

.end
