* Testcase 000022 — Full Analysis (sky130 tt corner)
* SKY130 model header — replaces the ideal level-1 .model cards
* Ships with the demo; the paths point at the local sky130 PDK checkout.
* NOTE: libs.tech/ngspice/all.spice sets ".option scale=1.0u", so every
* instance L/W below is written in microns WITHOUT a "u" suffix.
.param mc_mm_switch=0
.param mc_pr_switch=0
.include /home/idies/workspace/Temporary/xyu1/scratch/skywater-pdk-libs-sky130_fd_pr/models/corners/tt.spice
.include /home/idies/workspace/Temporary/xyu1/scratch/skywater-pdk-libs-sky130_fd_pr/models/r+c/res_typical__cap_typical.spice
.include /home/idies/workspace/Temporary/xyu1/scratch/skywater-pdk-libs-sky130_fd_pr/models/r+c/res_typical__cap_typical__lin.spice
.include /home/idies/workspace/Temporary/xyu1/scratch/skywater-pdk-libs-sky130_fd_pr/models/corners/tt/specialized_cells.spice
.model DIDEAL D   is=1e-14 n=1
.options reltol=1e-3 itl1=500 itl2=100

* Sources
VVDD VDD 0 1.8

* Circuit
I1 VDD N10 1u
I2 N8 GND 1u
I3 VDD N6 1u
XM1 N1 N0 VDD VDD sky130_fd_pr__pfet_01v8 l=0.5 w=5
XM2 N3 N4 GND GND sky130_fd_pr__nfet_01v8 l=0.5 w=5
XM3 N4 N4 GND GND sky130_fd_pr__nfet_01v8 l=0.5 w=5
XM4 N1 N3 GND GND sky130_fd_pr__nfet_01v8 l=0.5 w=5
XM5 N8 N8 N7 VDD sky130_fd_pr__pfet_01v8 l=0.5 w=5
XM6 N2 N5 GND GND sky130_fd_pr__nfet_01v8 l=0.5 w=5
XM7 N0 N2 VDD VDD sky130_fd_pr__pfet_01v8 l=0.5 w=5
XM8 N9 N9 GND GND sky130_fd_pr__nfet_01v8 l=0.5 w=5
XM9 N0 N6 N3 GND sky130_fd_pr__nfet_01v8 l=0.5 w=5
XM10 N3 N8 N0 VDD sky130_fd_pr__pfet_01v8 l=0.5 w=5
XM11 N5 N10 N10 VDD sky130_fd_pr__pfet_01v8 l=0.5 w=5
XM12 N2 N2 VDD VDD sky130_fd_pr__pfet_01v8 l=0.5 w=5
XM13 N6 N6 N9 GND sky130_fd_pr__nfet_01v8 l=0.5 w=5
XM14 N5 N5 GND GND sky130_fd_pr__nfet_01v8 l=0.5 w=5
XM15 N7 N7 VDD VDD sky130_fd_pr__pfet_01v8 l=0.5 w=5
XM16 N4 N4 N5 VDD sky130_fd_pr__pfet_01v8 l=0.5 w=5

.control
set filetype=ascii

op
let vdd_current = abs(i(VVDD))
let power_dc = vdd_current * 1.8
print power_dc

print all

let vout_dc = v(N5)
print vout_dc
let vout_dc = v(N2)
print vout_dc
quit
.endc

.end
