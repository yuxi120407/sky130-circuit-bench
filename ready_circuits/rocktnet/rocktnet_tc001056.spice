* Testcase 001056 — Full Analysis (sky130 tt corner)
* SKY130 model header — replaces the ideal level-1 .model cards
* Ships with the demo; the paths point at the local sky130 PDK checkout.
* NOTE: libs.tech/ngspice/all.spice sets ".option scale=1.0u", so every
* instance L/W below is written in microns WITHOUT a "u" suffix.
.param mc_mm_switch=0
.param mc_pr_switch=0
.include /home/idies/workspace/Temporary/xyu1/scratch/skywater-pdk-libs-sky130_fd_pr/models/corners/tt.spice
.include /home/idies/workspace/Temporary/xyu1/scratch/skywater-pdk-libs-sky130_fd_pr/models/r+c/res_typical__cap_typical.spice
.include /home/idies/workspace/Temporary/xyu1/scratch/skywater-pdk-libs-sky130_fd_pr/models/r+c/res_typical__cap_typical__lin.spice
.include /home/idies/workspace/Temporary/xyu1/scratch/skywater-pdk-libs-sky130_fd_pr/models/corners/tt/specialized_cells.spice
.model DIDEAL D   is=1e-14 n=1
.options reltol=1e-3 itl1=500 itl2=100

* Sources
VVDD VDD 0 1.8
VLABEL_NET_0 LABEL_NET_0 0 DC 0.9 AC 0.5
VLABEL_NET_6 LABEL_NET_6 0 DC 0.9 AC -0.5
VLABEL_NET_10 LABEL_NET_10 0 0.9

* Circuit
XM2 OUT N2 LABEL_NET_0 VDD sky130_fd_pr__pfet_01v8 l=0.5 w=5
XM3P N1 N1 GND GND sky130_fd_pr__nfet_01v8 l=0.5 w=5
XM5 N9 R1 GND GND sky130_fd_pr__nfet_01v8 l=0.5 w=5
XM5CAS N8 R2 N9 GND sky130_fd_pr__nfet_01v8 l=0.5 w=5
XMR1 N4 OUT GND GND sky130_fd_pr__nfet_01v8 l=0.5 w=5
XM8 N8 UP_B N2 VDD sky130_fd_pr__pfet_01v8 l=0.5 w=5
XM1 OUT N3 GND GND sky130_fd_pr__nfet_01v8 l=0.5 w=5
C2 N4 GND 1p
XM7 N6 DOWN N3 GND sky130_fd_pr__nfet_01v8 l=0.5 w=5
XM6P N0 N0 LABEL_NET_6 VDD sky130_fd_pr__pfet_01v8 l=0.5 w=5
XM4CAS N6 R3 N7 VDD sky130_fd_pr__pfet_01v8 l=0.5 w=5
XM4 N7 R4 GND VDD sky130_fd_pr__pfet_01v8 l=0.5 w=5
XM8P N8 UP N0 VDD sky130_fd_pr__pfet_01v8 l=0.5 w=5
XM6 N2 N2 LABEL_NET_10 VDD sky130_fd_pr__pfet_01v8 l=0.5 w=5
C1 N4 OUT 1p
XM3 N3 N3 GND GND sky130_fd_pr__nfet_01v8 l=0.5 w=5
XM7P N6 DOWN_B N1 GND sky130_fd_pr__nfet_01v8 l=0.5 w=5

.control
set filetype=ascii

op
let vdd_current = abs(i(VVDD))
let power_dc = vdd_current * 1.8
print power_dc

ac dec 100 1 10g
let vout_mag = vm(OUT)
let gain_db = db(vout_mag)
let dc_gain_db = gain_db[0]
print dc_gain_db

if dc_gain_db > 0
    meas ac ugbw WHEN gain_db=0 CROSS=1
end

quit
.endc

.end
