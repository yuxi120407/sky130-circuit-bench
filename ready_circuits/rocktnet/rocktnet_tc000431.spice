* Testcase 000431 — Full Analysis (sky130 tt corner)
* SKY130 model header — replaces the ideal level-1 .model cards
* Ships with the demo; the paths point at the local sky130 PDK checkout.
* NOTE: libs.tech/ngspice/all.spice sets ".option scale=1.0u", so every
* instance L/W below is written in microns WITHOUT a "u" suffix.
.param mc_mm_switch=0
.param mc_pr_switch=0
.include /home/idies/workspace/Temporary/xyu1/scratch/skywater-pdk-libs-sky130_fd_pr/models/corners/tt.spice
.include /home/idies/workspace/Temporary/xyu1/scratch/skywater-pdk-libs-sky130_fd_pr/models/r+c/res_typical__cap_typical.spice
.include /home/idies/workspace/Temporary/xyu1/scratch/skywater-pdk-libs-sky130_fd_pr/models/r+c/res_typical__cap_typical__lin.spice
.include /home/idies/workspace/Temporary/xyu1/scratch/skywater-pdk-libs-sky130_fd_pr/models/corners/tt/specialized_cells.spice
.model DIDEAL D   is=1e-14 n=1
.options reltol=1e-3 itl1=500 itl2=100

* Sources

* Circuit
I1 N7 GND 1u
XQ1 N5 N1 N7 0 sky130_fd_pr__npn_05v5_W1p00L1p00
XQ2 N2 N0 N7 0 sky130_fd_pr__npn_05v5_W1p00L1p00
L1 N3 N5 10n
L2 N2 N3 10n
R1 N6 N10 10k
XM1 N8 N5 N8 GND sky130_fd_pr__nfet_01v8 l=0.5 w=5
C1 N0 N5 1p
XM2 N8 N5 N8 GND sky130_fd_pr__nfet_01v8 l=0.5 w=5
C2 N2 N6 1p
XM3 N8 N2 N8 GND sky130_fd_pr__nfet_01v8 l=0.5 w=5
R2 N9 N10 10k
XM4 N8 N2 N8 GND sky130_fd_pr__nfet_01v8 l=0.5 w=5
C3 N1 N2 1p
D1 N9 N4 DIDEAL
C4 N5 N9 1p
D2 N6 N4 DIDEAL

.control
set filetype=ascii

op
let power_dc = 0
print power_dc
let dc_voltage = v(N0)
print dc_voltage

quit
.endc

.end
