* Testcase 000645 — Full Analysis (sky130 tt corner)
* SKY130 model header — replaces the ideal level-1 .model cards
* Ships with the demo; the paths point at the local sky130 PDK checkout.
* NOTE: libs.tech/ngspice/all.spice sets ".option scale=1.0u", so every
* instance L/W below is written in microns WITHOUT a "u" suffix.
.param mc_mm_switch=0
.param mc_pr_switch=0
.include /home/idies/workspace/Temporary/xyu1/scratch/skywater-pdk-libs-sky130_fd_pr/models/corners/tt.spice
.include /home/idies/workspace/Temporary/xyu1/scratch/skywater-pdk-libs-sky130_fd_pr/models/r+c/res_typical__cap_typical.spice
.include /home/idies/workspace/Temporary/xyu1/scratch/skywater-pdk-libs-sky130_fd_pr/models/r+c/res_typical__cap_typical__lin.spice
.include /home/idies/workspace/Temporary/xyu1/scratch/skywater-pdk-libs-sky130_fd_pr/models/corners/tt/specialized_cells.spice
.model DIDEAL D   is=1e-14 n=1
.options reltol=1e-3 itl1=500 itl2=100

* Sources
VINQ INQ 0 DC 0.9 AC 1 SIN(0.9 0.1 1MEG 0 0)
VIN IN 0 DC 0.9 AC 1 SIN(0.9 0.1 1MEG 0 0)

* Circuit
XQ1 GND N0 N2 0 sky130_fd_pr__npn_05v5_W1p00L1p00
XQ2 N2 N2 N7 0 sky130_fd_pr__npn_05v5_W1p00L1p00
I1 N12 VEE 1u
XQ3 N11 INQ N12 0 sky130_fd_pr__npn_05v5_W1p00L1p00
R1 VEE N10 10k
XQ4 GND N1 OUT 0 sky130_fd_pr__npn_05v5_W1p00L1p00
R2 OUTQ VEE 10k
XQ5 GND N11 N1 0 sky130_fd_pr__npn_05v5_W1p00L1p00
XQ6 N1 N1 N10 0 sky130_fd_pr__npn_05v5_W1p00L1p00
R3 VEE N7 10k
R4 OUT VEE 10k
XQ7 N0 IN N12 0 sky130_fd_pr__npn_05v5_W1p00L1p00
R5 INQ N10 10k
R6 N7 IN 10k
XQ8 GND N2 OUTQ 0 sky130_fd_pr__npn_05v5_W1p00L1p00
R7 N0 GND 10k
R8 GND N11 10k

.control
set filetype=ascii

op
let vdd_current = abs(i(VVDD))
let power_dc = vdd_current * 1.8
print power_dc

ac dec 100 1 10g
let vout_mag = vm(OUT)
let gain_db = db(vout_mag)
let dc_gain_db = gain_db[0]
print dc_gain_db

if dc_gain_db > 0
    meas ac ugbw WHEN gain_db=0 CROSS=1
end

quit
.endc

.end
