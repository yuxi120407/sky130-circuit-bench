* Testcase 000625 — Full Analysis (sky130 tt corner)
* SKY130 model header — replaces the ideal level-1 .model cards
* Ships with the demo; the paths point at the local sky130 PDK checkout.
* NOTE: libs.tech/ngspice/all.spice sets ".option scale=1.0u", so every
* instance L/W below is written in microns WITHOUT a "u" suffix.
.param mc_mm_switch=0
.param mc_pr_switch=0
.include /home/idies/workspace/Temporary/xyu1/scratch/skywater-pdk-libs-sky130_fd_pr/models/corners/tt.spice
.include /home/idies/workspace/Temporary/xyu1/scratch/skywater-pdk-libs-sky130_fd_pr/models/r+c/res_typical__cap_typical.spice
.include /home/idies/workspace/Temporary/xyu1/scratch/skywater-pdk-libs-sky130_fd_pr/models/r+c/res_typical__cap_typical__lin.spice
.include /home/idies/workspace/Temporary/xyu1/scratch/skywater-pdk-libs-sky130_fd_pr/models/corners/tt/specialized_cells.spice
.model DIDEAL D   is=1e-14 n=1
.options reltol=1e-3 itl1=500 itl2=100

* Sources
VLABEL_NET_0 LABEL_NET_0 0 DC 0.9 AC 0.5
VLABEL_NET_1 LABEL_NET_1 0 DC 0.9 AC -0.5
VLABEL_NET_2 LABEL_NET_2 0 0.9
VLABEL_NET_3 LABEL_NET_3 0 0.9
VLABEL_NET_4 LABEL_NET_4 0 0.9
VLABEL_NET_5 LABEL_NET_5 0 0.9
VLABEL_NET_6 LABEL_NET_6 0 0.9
VLABEL_NET_8 LABEL_NET_8 0 0.9
VLABEL_NET_7 LABEL_NET_7 0 0.9
VLABEL_NET_9 LABEL_NET_9 0 0.9
VLABEL_NET_11 LABEL_NET_11 0 0.9
VLABEL_NET_10 LABEL_NET_10 0 0.9

* Circuit
XM1 N2 LABEL_NET_0 N3 N3 sky130_fd_pr__nfet_01v8 l=0.5 w=5
L1 GND GND 10n
L2 GND GND 10n
XQ1 N0 N14 N2 0 sky130_fd_pr__npn_05v5_W1p00L1p00
R1 N14 LABEL_NET_1 10k
R2 GND GND 10k
XQ2 N10 N4 GND 0 sky130_fd_pr__npn_05v5_W1p00L1p00
R3 N8 LABEL_NET_2 10k
XQ3 N2 N6 N0 0 sky130_fd_pr__npn_05v5_W1p00L1p00
XQ4 N6 N5 N0 0 sky130_fd_pr__npn_05v5_W1p00L1p00
R4 N13 N13 10k
R5 GND GND 10k
R6 GND GND 10k
XQ5 N2 N8 N0 0 sky130_fd_pr__npn_05v5_W1p00L1p00
XQ6 N3 N13 GND 0 sky130_fd_pr__npn_05v5_W1p00L1p00
R7 GND GND 10k
R8 N5 LABEL_NET_3 10k
L3 N1 N2 10n
R9 N9 N11 10k
R10 N6 N6 10k
L4 N0 N1 10n
R11 N12 N15 10k
R12 N4 LABEL_NET_4 10k
C1 N7 N14 1p
C2 N1 N2 1p
R13 N7 N7 10k
XM2 N0 LABEL_NET_5 N10 N10 sky130_fd_pr__nfet_01v8 l=0.5 w=5
C3 N0 N1 1p
R14 N6 N6 10k
C4 N8 N9 1p
C5 N13 LABEL_NET_6 1p
XM3 N11 LABEL_NET_8 LABEL_NET_7 N11 sky130_fd_pr__nfet_01v8 l=0.5 w=5
C6 N5 N15 1p
C7 N4 LABEL_NET_9 1p
XM4 N12 LABEL_NET_11 LABEL_NET_10 N12 sky130_fd_pr__nfet_01v8 l=0.5 w=5

.control
set filetype=ascii

op
let power_dc = abs(i(VLABEL_NET_0)) * 1.8
print power_dc
let dc_voltage = v(N0)
print dc_voltage

quit
.endc

.end
