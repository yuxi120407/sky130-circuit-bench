* Testcase 000238 — Full Analysis (sky130 tt corner)
* SKY130 model header — replaces the ideal level-1 .model cards
* Ships with the demo; the paths point at the local sky130 PDK checkout.
* NOTE: libs.tech/ngspice/all.spice sets ".option scale=1.0u", so every
* instance L/W below is written in microns WITHOUT a "u" suffix.
.param mc_mm_switch=0
.param mc_pr_switch=0
.include /home/idies/workspace/Temporary/xyu1/scratch/skywater-pdk-libs-sky130_fd_pr/models/corners/tt.spice
.include /home/idies/workspace/Temporary/xyu1/scratch/skywater-pdk-libs-sky130_fd_pr/models/r+c/res_typical__cap_typical.spice
.include /home/idies/workspace/Temporary/xyu1/scratch/skywater-pdk-libs-sky130_fd_pr/models/r+c/res_typical__cap_typical__lin.spice
.include /home/idies/workspace/Temporary/xyu1/scratch/skywater-pdk-libs-sky130_fd_pr/models/corners/tt/specialized_cells.spice
.model DIDEAL D   is=1e-14 n=1
.options reltol=1e-3 itl1=500 itl2=100

* Sources
VVIN_PLUS VIN_PLUS 0 DC 0.9 AC 1 SIN(0.9 0.1 1MEG 0 0)

* Circuit
IBIAS N2 GND 1u
I2 N1 GND 1u
ITUNE N0 GND 1u
XQ1 N5 VIN_PLUS N1 0 sky130_fd_pr__npn_05v5_W1p00L1p00
XQ2 N4 VIN_PLUS N2 0 sky130_fd_pr__npn_05v5_W1p00L1p00
RE N1 N2 10k
XQ3 IOUT_PLUS N5 N0 0 sky130_fd_pr__npn_05v5_W1p00L1p00
XQ4 IOUT_MINUS N4 N0 0 sky130_fd_pr__npn_05v5_W1p00L1p00
D1 N3 N4 DIDEAL
D2 N3 N5 DIDEAL

.control
set filetype=ascii

op
let power_dc = abs(i(VVIN_PLUS)) * 1.8
print power_dc
let dc_voltage = v(N1)
print dc_voltage

quit
.endc

.end
