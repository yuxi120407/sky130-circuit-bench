* Testcase 000692 — Full Analysis (sky130 tt corner)
* SKY130 model header — replaces the ideal level-1 .model cards
* Ships with the demo; the paths point at the local sky130 PDK checkout.
* NOTE: libs.tech/ngspice/all.spice sets ".option scale=1.0u", so every
* instance L/W below is written in microns WITHOUT a "u" suffix.
.param mc_mm_switch=0
.param mc_pr_switch=0
.include /home/idies/workspace/Temporary/xyu1/scratch/skywater-pdk-libs-sky130_fd_pr/models/corners/tt.spice
.include /home/idies/workspace/Temporary/xyu1/scratch/skywater-pdk-libs-sky130_fd_pr/models/r+c/res_typical__cap_typical.spice
.include /home/idies/workspace/Temporary/xyu1/scratch/skywater-pdk-libs-sky130_fd_pr/models/r+c/res_typical__cap_typical__lin.spice
.include /home/idies/workspace/Temporary/xyu1/scratch/skywater-pdk-libs-sky130_fd_pr/models/corners/tt/specialized_cells.spice
.model DIDEAL D   is=1e-14 n=1
.options reltol=1e-3 itl1=500 itl2=100

* Sources
VIN_MINUS_2G IN_MINUS_2G 0 DC 0.9 AC 1 SIN(0.9 0.1 1MEG 0 0)
VIN_MINUS_5G IN_MINUS_5G 0 DC 0.9 AC 1 SIN(0.9 0.1 1MEG 0 0)
VIN_PLUS_5G IN_PLUS_5G 0 DC 0.9 AC 1 SIN(0.9 0.1 1MEG 0 0)
VIN_PLUS_2G IN_PLUS_2G 0 DC 0.9 AC 1 SIN(0.9 0.1 1MEG 0 0)

* Circuit
I1 N1 GND 1u
XM1 N0 LO_PLUS N3 GND sky130_fd_pr__nfet_01v8 l=0.5 w=5
XM2 N3 IN_MINUS_2G N1 GND sky130_fd_pr__nfet_01v8 l=0.5 w=5
XM3 N5 LO_MINUS N3 GND sky130_fd_pr__nfet_01v8 l=0.5 w=5
XM4 N0 LO_MINUS N2 GND sky130_fd_pr__nfet_01v8 l=0.5 w=5
XM5 N3 IN_MINUS_5G N1 GND sky130_fd_pr__nfet_01v8 l=0.5 w=5
XM6 N5 LO_PLUS N2 GND sky130_fd_pr__nfet_01v8 l=0.5 w=5
XM7 N2 IN_PLUS_5G N1 GND sky130_fd_pr__nfet_01v8 l=0.5 w=5
XM8 N2 IN_PLUS_2G N1 GND sky130_fd_pr__nfet_01v8 l=0.5 w=5
R1 N4 N5 10k
R2 N0 N4 10k

.control
set filetype=ascii

op
let power_dc = abs(i(VIN_MINUS_2G)) * 1.8
print power_dc
let dc_voltage = v(N0)
print dc_voltage

quit
.endc

.end
