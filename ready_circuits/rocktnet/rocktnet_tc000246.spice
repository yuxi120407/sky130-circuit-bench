* Testcase 000246 — Full Analysis (sky130 tt corner)
* SKY130 model header — replaces the ideal level-1 .model cards
* Ships with the demo; the paths point at the local sky130 PDK checkout.
* NOTE: libs.tech/ngspice/all.spice sets ".option scale=1.0u", so every
* instance L/W below is written in microns WITHOUT a "u" suffix.
.param mc_mm_switch=0
.param mc_pr_switch=0
.include /home/idies/workspace/Temporary/xyu1/scratch/skywater-pdk-libs-sky130_fd_pr/models/corners/tt.spice
.include /home/idies/workspace/Temporary/xyu1/scratch/skywater-pdk-libs-sky130_fd_pr/models/r+c/res_typical__cap_typical.spice
.include /home/idies/workspace/Temporary/xyu1/scratch/skywater-pdk-libs-sky130_fd_pr/models/r+c/res_typical__cap_typical__lin.spice
.include /home/idies/workspace/Temporary/xyu1/scratch/skywater-pdk-libs-sky130_fd_pr/models/corners/tt/specialized_cells.spice
.model DIDEAL D   is=1e-14 n=1
.options reltol=1e-3 itl1=500 itl2=100

* Sources
VVDD VDD 0 1.8
VVBIAS VBIAS 0 0.54
VLABEL_NET_0 LABEL_NET_0 0 0.9
VINP INP 0 DC 0.9 AC 1 SIN(0.9 0.1 1MEG 0 0)
VINN INN 0 DC 0.9 AC 1 SIN(0.9 0.1 1MEG 0 0)

* Circuit
XM1 N8 VBIAS GND GND sky130_fd_pr__nfet_01v8 l=0.5 w=5
XM2 N12 VBIAS GND GND sky130_fd_pr__nfet_01v8 l=0.5 w=5
R1 N0 N11 10k
XM3 N0 N1 N8 GND sky130_fd_pr__nfet_01v8 l=0.5 w=5
R2 N4 LABEL_NET_0 10k
XM4 N2 VBIAS GND GND sky130_fd_pr__nfet_01v8 l=0.5 w=5
XM5 N1 INP N2 GND sky130_fd_pr__nfet_01v8 l=0.5 w=5
R3 VDD N10 10k
R4 N3 GND 50
XM6 OUTP N4 N12 GND sky130_fd_pr__nfet_01v8 l=0.5 w=5
C1 N3 OUTP 1p
XM7 OUTN N0 N12 GND sky130_fd_pr__nfet_01v8 l=0.5 w=5
R5 VDD OUTN 50
R6 VDD OUTP 50
XM8 N4 N10 N8 GND sky130_fd_pr__nfet_01v8 l=0.5 w=5
R7 VDD N1 10k
R8 N13 GND 50
XM9 N10 INN N2 GND sky130_fd_pr__nfet_01v8 l=0.5 w=5
C2 N13 OUTN 1p
L1 VDD N11 10n
L2 VDD LABEL_NET_0 10n

.control
set filetype=ascii

op
let vdd_current = abs(i(VVDD))
let power_dc = vdd_current * 1.8
print power_dc

ac dec 100 1k 100g
let vout_mag = vm(OUTP)
let gain_db = db(vout_mag)

meas ac max_gain_db MAX gain_db
meas ac bw_3db WHEN gain_db='max_gain_db-3' CROSS=1

print max_gain_db bw_3db

quit
.endc

.end
