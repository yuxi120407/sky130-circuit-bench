* Testcase 001072 — Full Analysis (sky130 tt corner)
* SKY130 model header — replaces the ideal level-1 .model cards
* Ships with the demo; the paths point at the local sky130 PDK checkout.
* NOTE: libs.tech/ngspice/all.spice sets ".option scale=1.0u", so every
* instance L/W below is written in microns WITHOUT a "u" suffix.
.param mc_mm_switch=0
.param mc_pr_switch=0
.include /home/idies/workspace/Temporary/xyu1/scratch/skywater-pdk-libs-sky130_fd_pr/models/corners/tt.spice
.include /home/idies/workspace/Temporary/xyu1/scratch/skywater-pdk-libs-sky130_fd_pr/models/r+c/res_typical__cap_typical.spice
.include /home/idies/workspace/Temporary/xyu1/scratch/skywater-pdk-libs-sky130_fd_pr/models/r+c/res_typical__cap_typical__lin.spice
.include /home/idies/workspace/Temporary/xyu1/scratch/skywater-pdk-libs-sky130_fd_pr/models/corners/tt/specialized_cells.spice
.model DIDEAL D   is=1e-14 n=1
.options reltol=1e-3 itl1=500 itl2=100

* Sources
VLABEL_NET_0 LABEL_NET_0 0 DC 0.9 AC 0.5

* Circuit
C1 N10 N14 1p
L1 N4 N13 10n
R1 N9 N12 10k
C2 N4 N13 1p
R2 N6 N9 10k
XQ1 N6 N3 N8 0 sky130_fd_pr__npn_05v5_W1p00L1p00
R3 N1 N11 10k
C3 N11 N13 1p
C4 N1 N13 1p
XQ2 N12 N3 N0 0 sky130_fd_pr__npn_05v5_W1p00L1p00
XQ3 N0 N11 N2 0 sky130_fd_pr__npn_05v5_W1p00L1p00
XQ4 N8 N10 N7 0 sky130_fd_pr__npn_05v5_W1p00L1p00
R4 N1 N10 10k
XQ5 N6 N5 N0 0 sky130_fd_pr__npn_05v5_W1p00L1p00
XQ6 N12 N5 N8 0 sky130_fd_pr__npn_05v5_W1p00L1p00
L2 N14 LABEL_NET_0 10n
L3 N4 N7 10n
L4 N2 N4 10n

.control
set filetype=ascii

op
let power_dc = abs(i(VLABEL_NET_0)) * 1.8
print power_dc
let dc_voltage = v(N1)
print dc_voltage

quit
.endc

.end
