* Testcase 000061 — Full Analysis (sky130 tt corner)
* SKY130 model header — replaces the ideal level-1 .model cards
* Ships with the demo; the paths point at the local sky130 PDK checkout.
* NOTE: libs.tech/ngspice/all.spice sets ".option scale=1.0u", so every
* instance L/W below is written in microns WITHOUT a "u" suffix.
.param mc_mm_switch=0
.param mc_pr_switch=0
.include /home/idies/workspace/Temporary/xyu1/scratch/skywater-pdk-libs-sky130_fd_pr/models/corners/tt.spice
.include /home/idies/workspace/Temporary/xyu1/scratch/skywater-pdk-libs-sky130_fd_pr/models/r+c/res_typical__cap_typical.spice
.include /home/idies/workspace/Temporary/xyu1/scratch/skywater-pdk-libs-sky130_fd_pr/models/r+c/res_typical__cap_typical__lin.spice
.include /home/idies/workspace/Temporary/xyu1/scratch/skywater-pdk-libs-sky130_fd_pr/models/corners/tt/specialized_cells.spice
.model DIDEAL D   is=1e-14 n=1
.options reltol=1e-3 itl1=500 itl2=100

* Sources

* Circuit
XM1 N4 N12 GND GND sky130_fd_pr__nfet_01v8 l=0.5 w=5
XM2 N2 GND GND GND sky130_fd_pr__nfet_01v8 l=0.5 w=5
XM3 N4 N12 GND GND sky130_fd_pr__nfet_01v8 l=0.5 w=5
XM4 N0 GND GND GND sky130_fd_pr__nfet_01v8 l=0.5 w=5
XM5 N11 GND GND GND sky130_fd_pr__nfet_01v8 l=0.5 w=5
XM6 N7 GND GND GND sky130_fd_pr__nfet_01v8 l=0.5 w=5
XQ1 N10 N16 N4 0 sky130_fd_pr__npn_05v5_W1p00L1p00
XM7 N1 GND GND GND sky130_fd_pr__nfet_01v8 l=0.5 w=5
XM8 N3 N12 GND GND sky130_fd_pr__nfet_01v8 l=0.5 w=5
R1 N8 N10 10k
XQ2 N9 N16 N3 0 sky130_fd_pr__npn_05v5_W1p00L1p00
R2 N5 N8 10k
R3 N1 N3 10k
R4 N8 N9 10k
XQ3 N5 N7 N0 0 sky130_fd_pr__npn_05v5_W1p00L1p00
XQ4 N6 N4 N11 0 sky130_fd_pr__npn_05v5_W1p00L1p00
R5 N6 N8 10k
XQ5 N8 N5 N2 0 sky130_fd_pr__npn_05v5_W1p00L1p00
XQ6 N8 N13 N7 0 sky130_fd_pr__npn_05v5_W1p00L1p00
XQ7 N8 N6 N1 0 sky130_fd_pr__npn_05v5_W1p00L1p00
R6 N2 N4 10k
XQ8 N9 N4 N8 0 sky130_fd_pr__npn_05v5_W1p00L1p00

.control
set filetype=ascii

op
let power_dc = 0
print power_dc
let dc_voltage = v(N1)
print dc_voltage

quit
.endc

.end
