* Testcase 000256 — Full Analysis (sky130 tt corner)
* SKY130 model header — replaces the ideal level-1 .model cards
* Ships with the demo; the paths point at the local sky130 PDK checkout.
* NOTE: libs.tech/ngspice/all.spice sets ".option scale=1.0u", so every
* instance L/W below is written in microns WITHOUT a "u" suffix.
.param mc_mm_switch=0
.param mc_pr_switch=0
.include /home/idies/workspace/Temporary/xyu1/scratch/skywater-pdk-libs-sky130_fd_pr/models/corners/tt.spice
.include /home/idies/workspace/Temporary/xyu1/scratch/skywater-pdk-libs-sky130_fd_pr/models/r+c/res_typical__cap_typical.spice
.include /home/idies/workspace/Temporary/xyu1/scratch/skywater-pdk-libs-sky130_fd_pr/models/r+c/res_typical__cap_typical__lin.spice
.include /home/idies/workspace/Temporary/xyu1/scratch/skywater-pdk-libs-sky130_fd_pr/models/corners/tt/specialized_cells.spice
.model DIDEAL D   is=1e-14 n=1
.options reltol=1e-3 itl1=500 itl2=100

* Sources
VVDD VDD 0 1.8
VVSS VSS 0 0
VINPUT_P INPUT_P 0 DC 0.9 AC 1 SIN(0.9 0.1 1MEG 0 0)
VINPUT_N INPUT_N 0 DC 0.9 AC 1 SIN(0.9 0.1 1MEG 0 0)

* Circuit
R3 VDD N1 10k
R4 VDD N2 10k
RF1 N1 INPUT_P 10k
RF2 N2 INPUT_N 10k
R1 N3 VSS 10k
R2 N4 VSS 10k
XQ1 N1 N2 N3 0 sky130_fd_pr__npn_05v5_W1p00L1p00
XQ2 VDD N1 N4 0 sky130_fd_pr__npn_05v5_W1p00L1p00
XQ3 N1 INPUT_P N5 0 sky130_fd_pr__npn_05v5_W1p00L1p00
XQ6 N2 INPUT_N N5 0 sky130_fd_pr__npn_05v5_W1p00L1p00
XQ5 OUTPUT_P N4 N6 0 sky130_fd_pr__npn_05v5_W1p00L1p00
XQ4 OUTPUT_N N3 N6 0 sky130_fd_pr__npn_05v5_W1p00L1p00
I1 N5 VSS 1u
I2 N6 VSS 1u

.control
set filetype=ascii

op
let power_dc = abs(i(VVDD)) * 1.8
print power_dc

ac dec 100 1 10g
let vout_mag = vm(N5)
let gain_db = db(vout_mag)
let dc_gain_db = gain_db[0]
print dc_gain_db

if dc_gain_db > 0
    meas ac ugbw WHEN gain_db=0 CROSS=1
    print ugbw
end

quit
.endc

.end
