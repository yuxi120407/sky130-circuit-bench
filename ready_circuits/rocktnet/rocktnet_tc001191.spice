* Testcase 001191 — Full Analysis (sky130 tt corner)
* SKY130 model header — replaces the ideal level-1 .model cards
* Ships with the demo; the paths point at the local sky130 PDK checkout.
* NOTE: libs.tech/ngspice/all.spice sets ".option scale=1.0u", so every
* instance L/W below is written in microns WITHOUT a "u" suffix.
.param mc_mm_switch=0
.param mc_pr_switch=0
.include /home/idies/workspace/Temporary/xyu1/scratch/skywater-pdk-libs-sky130_fd_pr/models/corners/tt.spice
.include /home/idies/workspace/Temporary/xyu1/scratch/skywater-pdk-libs-sky130_fd_pr/models/r+c/res_typical__cap_typical.spice
.include /home/idies/workspace/Temporary/xyu1/scratch/skywater-pdk-libs-sky130_fd_pr/models/r+c/res_typical__cap_typical__lin.spice
.include /home/idies/workspace/Temporary/xyu1/scratch/skywater-pdk-libs-sky130_fd_pr/models/corners/tt/specialized_cells.spice
.model DIDEAL D   is=1e-14 n=1
.options reltol=1e-3 itl1=500 itl2=100

* Sources
VVDD VDD 0 1.8
VVSS VSS 0 DC 0 AC 0.5

* Circuit
I1 VDD N5 1u
XT7 GND GND VDD VDD sky130_fd_pr__pfet_01v8 l=0.5 w=5
CC N1 GND 1p
XT3D N2 N6 VDD VDD sky130_fd_pr__pfet_01v8 l=0.5 w=5
XT4A N1 N2 VSS GND sky130_fd_pr__nfet_01v8 l=0.5 w=5
XT8 N9 N5 VSS GND sky130_fd_pr__nfet_01v8 l=0.5 w=5
XT3A N7 N7 VDD VDD sky130_fd_pr__pfet_01v8 l=0.5 w=5
XT3C N1 N7 VDD VDD sky130_fd_pr__pfet_01v8 l=0.5 w=5
XT1B N3 OUT N9 GND sky130_fd_pr__nfet_01v8 l=0.5 w=5
XT9 GND N5 VSS GND sky130_fd_pr__nfet_01v8 l=0.5 w=5
XT6 OUT GND VDD VDD sky130_fd_pr__pfet_01v8 l=0.5 w=5
XT5 VSS N1 OUT VDD sky130_fd_pr__pfet_01v8 l=0.5 w=5
XT2A N7 OUT OUT GND sky130_fd_pr__nfet_01v8 l=0.5 w=5
XT4B N2 N2 VSS GND sky130_fd_pr__nfet_01v8 l=0.5 w=5
XT3B N6 N6 VDD VDD sky130_fd_pr__pfet_01v8 l=0.5 w=5
XT10 N5 N5 VSS GND sky130_fd_pr__nfet_01v8 l=0.5 w=5
XT2B N6 OUT N3 GND sky130_fd_pr__nfet_01v8 l=0.5 w=5
XT1A OUT VSET N9 GND sky130_fd_pr__nfet_01v8 l=0.5 w=5
C2 OUT N9 1p

.control
set filetype=ascii

op
let vdd_current = abs(i(VVDD))
let power_dc = vdd_current * 1.8
print power_dc

ac dec 100 1 10g
let vout_mag = vm(OUT)
let gain_db = db(vout_mag)
let dc_gain_db = gain_db[0]
print dc_gain_db

if dc_gain_db > 0
    meas ac ugbw WHEN gain_db=0 CROSS=1
end

quit
.endc

.end
