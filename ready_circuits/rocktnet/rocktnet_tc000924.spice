* Testcase 000924 — Full Analysis (sky130 tt corner)
* SKY130 model header — replaces the ideal level-1 .model cards
* Ships with the demo; the paths point at the local sky130 PDK checkout.
* NOTE: libs.tech/ngspice/all.spice sets ".option scale=1.0u", so every
* instance L/W below is written in microns WITHOUT a "u" suffix.
.param mc_mm_switch=0
.param mc_pr_switch=0
.include /home/idies/workspace/Temporary/xyu1/scratch/skywater-pdk-libs-sky130_fd_pr/models/corners/tt.spice
.include /home/idies/workspace/Temporary/xyu1/scratch/skywater-pdk-libs-sky130_fd_pr/models/r+c/res_typical__cap_typical.spice
.include /home/idies/workspace/Temporary/xyu1/scratch/skywater-pdk-libs-sky130_fd_pr/models/r+c/res_typical__cap_typical__lin.spice
.include /home/idies/workspace/Temporary/xyu1/scratch/skywater-pdk-libs-sky130_fd_pr/models/corners/tt/specialized_cells.spice
.model DIDEAL D   is=1e-14 n=1
.options reltol=1e-3 itl1=500 itl2=100

* Sources
VVDD VDD 0 1.8
VIN IN 0 DC 0.9 AC 1 SIN(0.9 0.1 1MEG 0 0)

* Circuit
XMP1 NET_MP1_D ENABLEB VDD VDD sky130_fd_pr__pfet_01v8 l=0.5 w=5
XMP2 NET_MP2_D ENABLEB VDD VDD sky130_fd_pr__pfet_01v8 l=0.5 w=5
XMP3 NET_MP3_D ENABLEB VDD VDD sky130_fd_pr__pfet_01v8 l=0.5 w=5
XMP4 NET_MP4_D ENABLEB VDD VDD sky130_fd_pr__pfet_01v8 l=0.5 w=5
XMCM1 ON ON NET_MP1_D VDD sky130_fd_pr__pfet_01v8 l=0.5 w=5
XMCM2 ON OP NET_MP2_D VDD sky130_fd_pr__pfet_01v8 l=0.5 w=5
XMCM3 OP ON NET_MP3_D VDD sky130_fd_pr__pfet_01v8 l=0.5 w=5
XMCM4 OP OP NET_MP4_D VDD sky130_fd_pr__pfet_01v8 l=0.5 w=5
XMIP1 ON IP NET_MN1_D GND sky130_fd_pr__nfet_01v8 l=0.5 w=5
XMIP2 ON IP NET_MN2_D GND sky130_fd_pr__nfet_01v8 l=0.5 w=5
XMIN2 OP IN NET_MN3_D GND sky130_fd_pr__nfet_01v8 l=0.5 w=5
XMIN1 OP IN NET_MN4_D GND sky130_fd_pr__nfet_01v8 l=0.5 w=5
XMN1 NET_MN1_D ENABLE GND GND sky130_fd_pr__nfet_01v8 l=0.5 w=5
XMN2 NET_MN2_D ENABLE GND GND sky130_fd_pr__nfet_01v8 l=0.5 w=5
XMN3 NET_MN3_D ENABLE GND GND sky130_fd_pr__nfet_01v8 l=0.5 w=5
XMN4 NET_MN4_D ENABLE GND GND sky130_fd_pr__nfet_01v8 l=0.5 w=5

.control
set filetype=ascii

op
let power_dc = abs(i(VVDD)) * 1.8
print power_dc

ac dec 100 1 10g
let vout_mag = vm(NET_MN3_D)
let gain_db = db(vout_mag)
let dc_gain_db = gain_db[0]
print dc_gain_db

if dc_gain_db > 0
    meas ac ugbw WHEN gain_db=0 CROSS=1
    print ugbw
end

quit
.endc

.end
