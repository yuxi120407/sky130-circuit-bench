* Testcase 001082 — Full Analysis (sky130 tt corner)
* SKY130 model header — replaces the ideal level-1 .model cards
* Ships with the demo; the paths point at the local sky130 PDK checkout.
* NOTE: libs.tech/ngspice/all.spice sets ".option scale=1.0u", so every
* instance L/W below is written in microns WITHOUT a "u" suffix.
.param mc_mm_switch=0
.param mc_pr_switch=0
.include /home/idies/workspace/Temporary/xyu1/scratch/skywater-pdk-libs-sky130_fd_pr/models/corners/tt.spice
.include /home/idies/workspace/Temporary/xyu1/scratch/skywater-pdk-libs-sky130_fd_pr/models/r+c/res_typical__cap_typical.spice
.include /home/idies/workspace/Temporary/xyu1/scratch/skywater-pdk-libs-sky130_fd_pr/models/r+c/res_typical__cap_typical__lin.spice
.include /home/idies/workspace/Temporary/xyu1/scratch/skywater-pdk-libs-sky130_fd_pr/models/corners/tt/specialized_cells.spice
.model DIDEAL D   is=1e-14 n=1
.options reltol=1e-3 itl1=500 itl2=100

* Sources
VVDD VDD 0 1.8

* Circuit
I1 N1 GND 1u
RDEC2 N1 N5 10k
RDEC1 N1 N2 10k
RO N0 N3 10k
XM1 N5 N2 N6 GND sky130_fd_pr__nfet_01v8 l=0.5 w=5
XM2B VDD VDD N1 GND sky130_fd_pr__nfet_01v8 l=0.5 w=5
LD VDD RFOUT 10n
XM2 RFOUT VDD N5 GND sky130_fd_pr__nfet_01v8 l=0.5 w=5
CO N0 N3 1p
LS N6 GND 10n

.control
set filetype=ascii

op
let vdd_current = abs(i(VVDD))
let power_dc = vdd_current * 1.8
print power_dc

print all

let vout_dc = v(N5)
print vout_dc
let vout_dc = v(N2)
print vout_dc
quit
.endc

.end
