* Testcase 000410 — Full Analysis (sky130 tt corner)
* SKY130 model header — replaces the ideal level-1 .model cards
* Ships with the demo; the paths point at the local sky130 PDK checkout.
* NOTE: libs.tech/ngspice/all.spice sets ".option scale=1.0u", so every
* instance L/W below is written in microns WITHOUT a "u" suffix.
.param mc_mm_switch=0
.param mc_pr_switch=0
.include /home/idies/workspace/Temporary/xyu1/scratch/skywater-pdk-libs-sky130_fd_pr/models/corners/tt.spice
.include /home/idies/workspace/Temporary/xyu1/scratch/skywater-pdk-libs-sky130_fd_pr/models/r+c/res_typical__cap_typical.spice
.include /home/idies/workspace/Temporary/xyu1/scratch/skywater-pdk-libs-sky130_fd_pr/models/r+c/res_typical__cap_typical__lin.spice
.include /home/idies/workspace/Temporary/xyu1/scratch/skywater-pdk-libs-sky130_fd_pr/models/corners/tt/specialized_cells.spice
.model DIDEAL D   is=1e-14 n=1
.options reltol=1e-3 itl1=500 itl2=100

* Sources
VVDD VDD 0 1.8

* Circuit
XM8 R_C P_C V_BOOT VDD sky130_fd_pr__pfet_01v8 l=0.5 w=5
XM13 D_C R_C V_BOOT VDD sky130_fd_pr__pfet_01v8 l=0.5 w=5
XM7 S_C D_C V_BOOT VDD sky130_fd_pr__pfet_01v8 l=0.5 w=5
XM14 P_C S_C V_BOOT VDD sky130_fd_pr__pfet_01v8 l=0.5 w=5
XM5 S_B V_OUT S_C VDD sky130_fd_pr__pfet_01v8 l=0.5 w=5
XM6 R_B V_OUT R_C VDD sky130_fd_pr__pfet_01v8 l=0.5 w=5
XM11 D_B V_OUT D_C VDD sky130_fd_pr__pfet_01v8 l=0.5 w=5
XM12 P_B V_OUT P_C VDD sky130_fd_pr__pfet_01v8 l=0.5 w=5
XM3 S_B SET GND GND sky130_fd_pr__nfet_01v8 l=0.5 w=5
D1 GND P_B DIDEAL
D2 GND D_B DIDEAL
XM4 R_B RESET GND GND sky130_fd_pr__nfet_01v8 l=0.5 w=5
D3 GND S_B DIDEAL
D4 GND R_B DIDEAL
XM10 P_B PRECHARGE GND GND sky130_fd_pr__nfet_01v8 l=0.5 w=5
XM9 D_B DISCHARGE GND GND sky130_fd_pr__nfet_01v8 l=0.5 w=5

.control
set filetype=ascii

op
let vdd_current = abs(i(VVDD))
let power_dc = vdd_current * 1.8
print power_dc

print all

let vout_dc = v(V_OUT)
print vout_dc
let vout_dc = v(P_B)
print vout_dc
quit
.endc

.end
