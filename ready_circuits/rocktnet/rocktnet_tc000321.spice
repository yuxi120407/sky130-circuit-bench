* Testcase 000321 — Full Analysis (sky130 tt corner)
* SKY130 model header — replaces the ideal level-1 .model cards
* Ships with the demo; the paths point at the local sky130 PDK checkout.
* NOTE: libs.tech/ngspice/all.spice sets ".option scale=1.0u", so every
* instance L/W below is written in microns WITHOUT a "u" suffix.
.param mc_mm_switch=0
.param mc_pr_switch=0
.include /home/idies/workspace/Temporary/xyu1/scratch/skywater-pdk-libs-sky130_fd_pr/models/corners/tt.spice
.include /home/idies/workspace/Temporary/xyu1/scratch/skywater-pdk-libs-sky130_fd_pr/models/r+c/res_typical__cap_typical.spice
.include /home/idies/workspace/Temporary/xyu1/scratch/skywater-pdk-libs-sky130_fd_pr/models/r+c/res_typical__cap_typical__lin.spice
.include /home/idies/workspace/Temporary/xyu1/scratch/skywater-pdk-libs-sky130_fd_pr/models/corners/tt/specialized_cells.spice
.model DIDEAL D   is=1e-14 n=1
.options reltol=1e-3 itl1=500 itl2=100

* Sources
VVDD VDD 0 1.8
VINP INP 0 DC 0.9 AC 1 SIN(0.9 0.1 1MEG 0 0)
VLABEL_NET_1 LABEL_NET_1 0 0.9
VINM INM 0 DC 0.9 AC 1 SIN(0.9 0.1 1MEG 0 0)
VLABEL_NET_3 LABEL_NET_3 0 0.9
VLABEL_NET_4 LABEL_NET_4 0 0.9
VLABEL_NET_5 LABEL_NET_5 0 0.9

* Circuit
XM1 N0 N0 VDDA VDD sky130_fd_pr__pfet_01v8 l=0.5 w=5
XM2 N6 N0 N1 GND sky130_fd_pr__nfet_01v8 l=0.5 w=5
XM3 N8 N0 N1 GND sky130_fd_pr__nfet_01v8 l=0.5 w=5
XM4 N4 INP N11 GND sky130_fd_pr__nfet_01v8 l=0.5 w=5
XM5 N0 N4 N4 GND sky130_fd_pr__nfet_01v8 l=0.5 w=5
XM6 Q VDD VDD VDD sky130_fd_pr__pfet_01v8 l=0.5 w=5
I1 N11 GND 1u
XM7 Q LABEL_NET_1 VDD VDD sky130_fd_pr__pfet_01v8 l=0.5 w=5
XM8 N7 INM N5 GND sky130_fd_pr__nfet_01v8 l=0.5 w=5
XM9 N1 CLK GND GND sky130_fd_pr__nfet_01v8 l=0.5 w=5
XM10 N0 N7 N7 GND sky130_fd_pr__nfet_01v8 l=0.5 w=5
XM11 N0 LABEL_NET_3 VDDA VDD sky130_fd_pr__pfet_01v8 l=0.5 w=5
XM12 Q CLK GND GND sky130_fd_pr__nfet_01v8 l=0.5 w=5
XM13 N0 LABEL_NET_4 VDDA VDD sky130_fd_pr__pfet_01v8 l=0.5 w=5
XM14 N0 LABEL_NET_5 VDDA VDD sky130_fd_pr__pfet_01v8 l=0.5 w=5
XM15 QB VDD VDD VDD sky130_fd_pr__pfet_01v8 l=0.5 w=5
XM16 N7 N7 N5 GND sky130_fd_pr__nfet_01v8 l=0.5 w=5
XM17 N4 REFP N11 GND sky130_fd_pr__nfet_01v8 l=0.5 w=5
XM18 N8 CLK VDD VDD sky130_fd_pr__pfet_01v8 l=0.5 w=5
XM19 QB CLK VDD VDD sky130_fd_pr__pfet_01v8 l=0.5 w=5
XM20 VDD VDD VDD VDD sky130_fd_pr__pfet_01v8 l=0.5 w=5
XM21 N6 CLK VDD VDD sky130_fd_pr__pfet_01v8 l=0.5 w=5
I2 N5 GND 1u
XM22 VDD VDD N8 GND sky130_fd_pr__nfet_01v8 l=0.5 w=5
XM23 VDD VDD VDD VDD sky130_fd_pr__pfet_01v8 l=0.5 w=5
XM24 QB VDD GND GND sky130_fd_pr__nfet_01v8 l=0.5 w=5
XM25 VDD VDD N6 GND sky130_fd_pr__nfet_01v8 l=0.5 w=5
XM26 N0 N7 N0 GND sky130_fd_pr__nfet_01v8 l=0.5 w=5
XM27 N0 N4 N4 GND sky130_fd_pr__nfet_01v8 l=0.5 w=5
XM28 N0 N0 N0 VDD sky130_fd_pr__pfet_01v8 l=0.5 w=5
XM29 CLK VDD Q VDD sky130_fd_pr__pfet_01v8 l=0.5 w=5

.control
set filetype=ascii

op
let vdd_current = abs(i(VVDD))
let power_dc = vdd_current * 1.8
print power_dc

print all

let vout_dc = v(N0)
print vout_dc
let vout_dc = v(CLK)
print vout_dc
quit
.endc

.end
