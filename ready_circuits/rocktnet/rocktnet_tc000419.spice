* Testcase 000419 — Full Analysis (sky130 tt corner)
* SKY130 model header — replaces the ideal level-1 .model cards
* Ships with the demo; the paths point at the local sky130 PDK checkout.
* NOTE: libs.tech/ngspice/all.spice sets ".option scale=1.0u", so every
* instance L/W below is written in microns WITHOUT a "u" suffix.
.param mc_mm_switch=0
.param mc_pr_switch=0
.include /home/idies/workspace/Temporary/xyu1/scratch/skywater-pdk-libs-sky130_fd_pr/models/corners/tt.spice
.include /home/idies/workspace/Temporary/xyu1/scratch/skywater-pdk-libs-sky130_fd_pr/models/r+c/res_typical__cap_typical.spice
.include /home/idies/workspace/Temporary/xyu1/scratch/skywater-pdk-libs-sky130_fd_pr/models/r+c/res_typical__cap_typical__lin.spice
.include /home/idies/workspace/Temporary/xyu1/scratch/skywater-pdk-libs-sky130_fd_pr/models/corners/tt/specialized_cells.spice
.model DIDEAL D   is=1e-14 n=1
.options reltol=1e-3 itl1=500 itl2=100

* Sources
VLABEL_NET_0 LABEL_NET_0 0 0.9
VLABEL_NET_1 LABEL_NET_1 0 0.9
VLABEL_NET_2 LABEL_NET_2 0 0.9
VLABEL_NET_3 LABEL_NET_3 0 0.9
VLABEL_NET_4 LABEL_NET_4 0 0.9

* Circuit
I1 N2 LABEL_NET_0 1u
I2 N9 LABEL_NET_1 1u
I3 N10 LABEL_NET_2 1u
I4 N6 LABEL_NET_3 1u
XQ1 N0 N3 N4 0 sky130_fd_pr__npn_05v5_W1p00L1p00
I5 N8 LABEL_NET_4 1u
XQ2 N5 N2 N6 0 sky130_fd_pr__npn_05v5_W1p00L1p00
XQ3 N1 N11 N12 0 sky130_fd_pr__npn_05v5_W1p00L1p00
R1 N4 N9 10k
XQ4 N5 N1 N2 0 sky130_fd_pr__npn_05v5_W1p00L1p00
R2 N9 N12 10k
XQ5 N7 N8 N10 0 sky130_fd_pr__npn_05v5_W1p00L1p00
XQ6 N7 N0 N8 0 sky130_fd_pr__npn_05v5_W1p00L1p00

.control
set filetype=ascii

op
let power_dc = abs(i(VLABEL_NET_0)) * 1.8
print power_dc
let dc_voltage = v(N12)
print dc_voltage

quit
.endc

.end
