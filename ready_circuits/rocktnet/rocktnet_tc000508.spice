* Testcase 000508 — Full Analysis (sky130 tt corner)
* SKY130 model header — replaces the ideal level-1 .model cards
* Ships with the demo; the paths point at the local sky130 PDK checkout.
* NOTE: libs.tech/ngspice/all.spice sets ".option scale=1.0u", so every
* instance L/W below is written in microns WITHOUT a "u" suffix.
.param mc_mm_switch=0
.param mc_pr_switch=0
.include /home/idies/workspace/Temporary/xyu1/scratch/skywater-pdk-libs-sky130_fd_pr/models/corners/tt.spice
.include /home/idies/workspace/Temporary/xyu1/scratch/skywater-pdk-libs-sky130_fd_pr/models/r+c/res_typical__cap_typical.spice
.include /home/idies/workspace/Temporary/xyu1/scratch/skywater-pdk-libs-sky130_fd_pr/models/r+c/res_typical__cap_typical__lin.spice
.include /home/idies/workspace/Temporary/xyu1/scratch/skywater-pdk-libs-sky130_fd_pr/models/corners/tt/specialized_cells.spice
.model DIDEAL D   is=1e-14 n=1
.options reltol=1e-3 itl1=500 itl2=100

* Sources
VVDD VDD 0 1.8
VIN IN 0 DC 0.9 AC 1

* Circuit
XM1 IP N3 GND GND sky130_fd_pr__nfet_01v8 l=0.5 w=5
XM2 IN N0 GND GND sky130_fd_pr__nfet_01v8 l=0.5 w=5
XM3 IC N2 GND GND sky130_fd_pr__nfet_01v8 l=0.5 w=5
C1 N0 VDD 1p
C2 N0 VN 1p
C3 N3 VDD 1p
C4 N0 VN 1p
C5 N2 VP 1p
C6 VN N2 1p
C7 N3 VP 1p
C8 N2 VDD 1p
C9 N3 VP 1p

.control
set filetype=ascii

op
let power_dc = abs(i(VVDD)) * 1.8
print power_dc

ac dec 100 1 10g
let gain_N2 = db(vm(N2))
let gain_IP = db(vm(IP))
let gain_IC = db(vm(IC))
let gain_N0 = db(vm(N0))
let gain_N3 = db(vm(N3))
meas ac max_gain_N2 MAX gain_N2
meas ac max_gain_IP MAX gain_IP
meas ac max_gain_IC MAX gain_IC
meas ac max_gain_N0 MAX gain_N0
meas ac max_gain_N3 MAX gain_N3

* Use first probe node for standard metrics
let gain_db = db(vm(N2))
meas ac dc_gain_db FIND gain_db AT=1
meas ac ugbw WHEN gain_db=0 CROSS=1
let vout_dc = v(N2)

print dc_gain_db ugbw vout_dc gain_N2 gain_IP gain_IC gain_N0 gain_N3

quit
.endc

.end
