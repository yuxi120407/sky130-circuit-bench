* Testcase 000620 — Full Analysis (sky130 tt corner)
* SKY130 model header — replaces the ideal level-1 .model cards
* Ships with the demo; the paths point at the local sky130 PDK checkout.
* NOTE: libs.tech/ngspice/all.spice sets ".option scale=1.0u", so every
* instance L/W below is written in microns WITHOUT a "u" suffix.
.param mc_mm_switch=0
.param mc_pr_switch=0
.include /home/idies/workspace/Temporary/xyu1/scratch/skywater-pdk-libs-sky130_fd_pr/models/corners/tt.spice
.include /home/idies/workspace/Temporary/xyu1/scratch/skywater-pdk-libs-sky130_fd_pr/models/r+c/res_typical__cap_typical.spice
.include /home/idies/workspace/Temporary/xyu1/scratch/skywater-pdk-libs-sky130_fd_pr/models/r+c/res_typical__cap_typical__lin.spice
.include /home/idies/workspace/Temporary/xyu1/scratch/skywater-pdk-libs-sky130_fd_pr/models/corners/tt/specialized_cells.spice
.model DIDEAL D   is=1e-14 n=1
.options reltol=1e-3 itl1=500 itl2=100

* Sources
VVDD VDD 0 1.8

* Circuit
XM1 GND CK GND GND sky130_fd_pr__nfet_01v8 l=0.5 w=5
XM2 GND N0B GND GND sky130_fd_pr__nfet_01v8 l=0.5 w=5
XM3 GND GND GND GND sky130_fd_pr__nfet_01v8 l=0.5 w=5
XM4 VDD GND GND GND sky130_fd_pr__nfet_01v8 l=0.5 w=5
XM5 N2 N0B GND GND sky130_fd_pr__nfet_01v8 l=0.5 w=5
XM6 GND N0A GND GND sky130_fd_pr__nfet_01v8 l=0.5 w=5
XM7 VDD N0B VDD VDD sky130_fd_pr__pfet_01v8 l=0.5 w=5
XM8 N0B N2 VDD VDD sky130_fd_pr__pfet_01v8 l=0.5 w=5
XM9 GND N0A VDD VDD sky130_fd_pr__pfet_01v8 l=0.5 w=5
XM10 N5 Q GND GND sky130_fd_pr__nfet_01v8 l=0.5 w=5
XM11 GND CK VDD VDD sky130_fd_pr__pfet_01v8 l=0.5 w=5
XM12 VDD N2 GND VDD sky130_fd_pr__pfet_01v8 l=0.5 w=5
XM13 GND GND VDD VDD sky130_fd_pr__pfet_01v8 l=0.5 w=5
XM14 D GND N0A VDD sky130_fd_pr__pfet_01v8 l=0.5 w=5
XM15 GND GND GND GND sky130_fd_pr__nfet_01v8 l=0.5 w=5
XM16 GND N1A GND GND sky130_fd_pr__nfet_01v8 l=0.5 w=5
XM17 GND VDD GND VDD sky130_fd_pr__pfet_01v8 l=0.5 w=5
XM18 GND N0B VDD VDD sky130_fd_pr__pfet_01v8 l=0.5 w=5
XM19 D GND N0B VDD sky130_fd_pr__pfet_01v8 l=0.5 w=5
XM20 N0B GND N5 GND sky130_fd_pr__nfet_01v8 l=0.5 w=5
XM21 D GND N0B GND sky130_fd_pr__nfet_01v8 l=0.5 w=5
XM22 D GND N0A GND sky130_fd_pr__nfet_01v8 l=0.5 w=5

.control
set filetype=ascii

op
let vdd_current = abs(i(VVDD))
let power_dc = vdd_current * 1.8
print power_dc

print all

let vout_dc = v(N0B)
print vout_dc
let vout_dc = v(N2)
print vout_dc
quit
.endc

.end
