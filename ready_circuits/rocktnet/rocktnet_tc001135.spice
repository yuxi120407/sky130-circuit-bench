* Testcase 001135 — Full Analysis (sky130 tt corner)
* SKY130 model header — replaces the ideal level-1 .model cards
* Ships with the demo; the paths point at the local sky130 PDK checkout.
* NOTE: libs.tech/ngspice/all.spice sets ".option scale=1.0u", so every
* instance L/W below is written in microns WITHOUT a "u" suffix.
.param mc_mm_switch=0
.param mc_pr_switch=0
.include /home/idies/workspace/Temporary/xyu1/scratch/skywater-pdk-libs-sky130_fd_pr/models/corners/tt.spice
.include /home/idies/workspace/Temporary/xyu1/scratch/skywater-pdk-libs-sky130_fd_pr/models/r+c/res_typical__cap_typical.spice
.include /home/idies/workspace/Temporary/xyu1/scratch/skywater-pdk-libs-sky130_fd_pr/models/r+c/res_typical__cap_typical__lin.spice
.include /home/idies/workspace/Temporary/xyu1/scratch/skywater-pdk-libs-sky130_fd_pr/models/corners/tt/specialized_cells.spice
.model DIDEAL D   is=1e-14 n=1
.options reltol=1e-3 itl1=500 itl2=100

* Sources
VVDD VDD 0 1.8

* Circuit
XM1 N6 N4 N9 GND sky130_fd_pr__nfet_01v8 l=0.5 w=5
XM2 N6 N6 VDD VDD sky130_fd_pr__pfet_01v8 l=0.5 w=5
XM3 N6 N6 N0 GND sky130_fd_pr__nfet_01v8 l=0.5 w=5
XM4 N9 N1 GND GND sky130_fd_pr__nfet_01v8 l=0.5 w=5
XM5 N6 VC N10 GND sky130_fd_pr__nfet_01v8 l=0.5 w=5
XM6 N3 N0 GND GND sky130_fd_pr__nfet_01v8 l=0.5 w=5
XM7 VN1 N6 VDD VDD sky130_fd_pr__pfet_01v8 l=0.5 w=5
XM8 N1 N1 GND GND sky130_fd_pr__nfet_01v8 l=0.5 w=5
XM9 N0 N0 GND GND sky130_fd_pr__nfet_01v8 l=0.5 w=5
XM10 N4 N6 N3 GND sky130_fd_pr__nfet_01v8 l=0.5 w=5
I1 VDD N4 1u
XM11 N4 N4 N1 GND sky130_fd_pr__nfet_01v8 l=0.5 w=5
XM12 VN1 VN1 VN2 GND sky130_fd_pr__nfet_01v8 l=0.5 w=5
R1 N10 GND 10k
XM13 VN2 VN2 GND GND sky130_fd_pr__nfet_01v8 l=0.5 w=5
XM14 N6 VC N8 VDD sky130_fd_pr__pfet_01v8 l=0.5 w=5
R2 VDD N8 10k

.control
set filetype=ascii

op
let vdd_current = abs(i(VVDD))
let power_dc = vdd_current * 1.8
let vout_dc = v(N10)
print power_dc vout_dc

quit
.endc

.end
