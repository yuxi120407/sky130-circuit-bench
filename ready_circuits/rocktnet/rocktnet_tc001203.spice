* Testcase 001203 — Full Analysis (sky130 tt corner)
* SKY130 model header — replaces the ideal level-1 .model cards
* Ships with the demo; the paths point at the local sky130 PDK checkout.
* NOTE: libs.tech/ngspice/all.spice sets ".option scale=1.0u", so every
* instance L/W below is written in microns WITHOUT a "u" suffix.
.param mc_mm_switch=0
.param mc_pr_switch=0
.include /home/idies/workspace/Temporary/xyu1/scratch/skywater-pdk-libs-sky130_fd_pr/models/corners/tt.spice
.include /home/idies/workspace/Temporary/xyu1/scratch/skywater-pdk-libs-sky130_fd_pr/models/r+c/res_typical__cap_typical.spice
.include /home/idies/workspace/Temporary/xyu1/scratch/skywater-pdk-libs-sky130_fd_pr/models/r+c/res_typical__cap_typical__lin.spice
.include /home/idies/workspace/Temporary/xyu1/scratch/skywater-pdk-libs-sky130_fd_pr/models/corners/tt/specialized_cells.spice
.model DIDEAL D   is=1e-14 n=1
.options reltol=1e-3 itl1=500 itl2=100

* Sources
VVDD VDD 0 1.8
VIN_L1 IN_L1 0 DC 0.9 AC 1 SIN(0.9 0.1 1MEG 0 0)
VIN_L2 IN_L2 0 DC 0.9 AC 1 SIN(0.9 0.1 1MEG 0 0)
VIN_R1 IN_R1 0 DC 0.9 AC 1 SIN(0.9 0.1 1MEG 0 0)
VIN_R2 IN_R2 0 DC 0.9 AC 1 SIN(0.9 0.1 1MEG 0 0)

* Circuit
XP1 P1 CK VDD VDD sky130_fd_pr__pfet_01v8 l=0.5 w=5
XP2 P2 CK VDD VDD sky130_fd_pr__pfet_01v8 l=0.5 w=5
XP4 OUT_BAR CK_BAR P1 VDD sky130_fd_pr__pfet_01v8 l=0.5 w=5
XP3 OUT CK_BAR P2 VDD sky130_fd_pr__pfet_01v8 l=0.5 w=5
XM4 P1 IN_L1 N_L_MID GND sky130_fd_pr__nfet_01v8 l=0.5 w=5
XM1 N_L_MID IN_L2 N_TAIL GND sky130_fd_pr__nfet_01v8 l=0.5 w=5
XM9 P2 IN_R1 N_TAIL GND sky130_fd_pr__nfet_01v8 l=0.5 w=5
XM2 P2 IN_R2 N_TAIL GND sky130_fd_pr__nfet_01v8 l=0.5 w=5
XM3 N_TAIL N_C GND GND sky130_fd_pr__nfet_01v8 l=0.5 w=5
XM6 N_C N_C GND GND sky130_fd_pr__nfet_01v8 l=0.5 w=5
C1 CK N_C 1p

.control
set filetype=ascii

op
let vdd_current = abs(i(VVDD))
let power_dc = vdd_current * 1.8
print power_dc

ac dec 100 1 10g
let vout_mag = vm(OUT)
let gain_db = db(vout_mag)
let dc_gain_db = gain_db[0]
print dc_gain_db

if dc_gain_db > 0
    meas ac ugbw WHEN gain_db=0 CROSS=1
end

quit
.endc

.end
