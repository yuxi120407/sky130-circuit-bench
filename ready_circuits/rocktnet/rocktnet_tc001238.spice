* Testcase 001238 — Full Analysis (sky130 tt corner)
* SKY130 model header — replaces the ideal level-1 .model cards
* Ships with the demo; the paths point at the local sky130 PDK checkout.
* NOTE: libs.tech/ngspice/all.spice sets ".option scale=1.0u", so every
* instance L/W below is written in microns WITHOUT a "u" suffix.
.param mc_mm_switch=0
.param mc_pr_switch=0
.include /home/idies/workspace/Temporary/xyu1/scratch/skywater-pdk-libs-sky130_fd_pr/models/corners/tt.spice
.include /home/idies/workspace/Temporary/xyu1/scratch/skywater-pdk-libs-sky130_fd_pr/models/r+c/res_typical__cap_typical.spice
.include /home/idies/workspace/Temporary/xyu1/scratch/skywater-pdk-libs-sky130_fd_pr/models/r+c/res_typical__cap_typical__lin.spice
.include /home/idies/workspace/Temporary/xyu1/scratch/skywater-pdk-libs-sky130_fd_pr/models/corners/tt/specialized_cells.spice
.model DIDEAL D   is=1e-14 n=1
.options reltol=1e-3 itl1=500 itl2=100

* Sources
VVDD VDD 0 1.8
VVB2 VB2 0 DC 0.54 AC 0.5
VVB1 VB1 0 0.54

* Circuit
XMC14 N0 N0 VDD VDD sky130_fd_pr__pfet_01v8 l=0.5 w=5
XMC11 N5 N5 VDD VDD sky130_fd_pr__pfet_01v8 l=0.5 w=5
XMC2 N0 VB2 N1 GND sky130_fd_pr__nfet_01v8 l=0.5 w=5
XMC5 OUT_N VB2 N4 GND sky130_fd_pr__nfet_01v8 l=0.5 w=5
XMC4 N5 OUT_P N1 GND sky130_fd_pr__nfet_01v8 l=0.5 w=5
XMC7 N4 VB1 GND GND sky130_fd_pr__nfet_01v8 l=0.5 w=5
XMC12 OUT_N N0 VDD VDD sky130_fd_pr__pfet_01v8 l=0.5 w=5
XMC8 N1 VB1 GND GND sky130_fd_pr__nfet_01v8 l=0.5 w=5
XMC10 N6 N6 VDD VDD sky130_fd_pr__pfet_01v8 l=0.5 w=5
XMC13 N0 N0 VDD VDD sky130_fd_pr__pfet_01v8 l=0.5 w=5
XMC3 N0 VB2 N1 GND sky130_fd_pr__nfet_01v8 l=0.5 w=5
XMC1 N6 OUT_N N1 GND sky130_fd_pr__nfet_01v8 l=0.5 w=5
XMC15 OUT_P N0 VDD VDD sky130_fd_pr__pfet_01v8 l=0.5 w=5
XMC9 N3 VB1 GND GND sky130_fd_pr__nfet_01v8 l=0.5 w=5
XMC6 OUT_P VB2 N3 GND sky130_fd_pr__nfet_01v8 l=0.5 w=5

.control
set filetype=ascii

op
let power_dc = abs(i(VVDD)) * 1.8
print power_dc

ac dec 100 1 10g
let vout_mag = vm(N1)
let gain_db = db(vout_mag)
let dc_gain_db = gain_db[0]
print dc_gain_db

if dc_gain_db > 0
    meas ac ugbw WHEN gain_db=0 CROSS=1
    print ugbw
end

quit
.endc

.end
