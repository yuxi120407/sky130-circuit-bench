* Testcase 000184 — Full Analysis (sky130 tt corner)
* SKY130 model header — replaces the ideal level-1 .model cards
* Ships with the demo; the paths point at the local sky130 PDK checkout.
* NOTE: libs.tech/ngspice/all.spice sets ".option scale=1.0u", so every
* instance L/W below is written in microns WITHOUT a "u" suffix.
.param mc_mm_switch=0
.param mc_pr_switch=0
.include /home/idies/workspace/Temporary/xyu1/scratch/skywater-pdk-libs-sky130_fd_pr/models/corners/tt.spice
.include /home/idies/workspace/Temporary/xyu1/scratch/skywater-pdk-libs-sky130_fd_pr/models/r+c/res_typical__cap_typical.spice
.include /home/idies/workspace/Temporary/xyu1/scratch/skywater-pdk-libs-sky130_fd_pr/models/r+c/res_typical__cap_typical__lin.spice
.include /home/idies/workspace/Temporary/xyu1/scratch/skywater-pdk-libs-sky130_fd_pr/models/corners/tt/specialized_cells.spice
.model DIDEAL D   is=1e-14 n=1
.options reltol=1e-3 itl1=500 itl2=100

* Sources
VVDD VDD 0 1.8
VIN IN 0 DC 0.9 AC 1 SIN(0.9 0.1 1MEG 0 0)
VINDUMMY INDUMMY 0 DC 0.9 AC 1 SIN(0.9 0.1 1MEG 0 0)

* Circuit
IB VDD N_BIAS 1u
XQB0 N_BIAS N_BIAS GND 0 sky130_fd_pr__npn_05v5_W1p00L1p00
XQ1 VDD IN N_Q2B 0 sky130_fd_pr__npn_05v5_W1p00L1p00
XQB1 N_Q2B N_BIAS GND 0 sky130_fd_pr__npn_05v5_W1p00L1p00
XQ2 N_Q2C N_Q2B N_Q2E 0 sky130_fd_pr__npn_05v5_W1p00L1p00
R1 N_Q2E INDUMMY 10k
R2 VDD N_Q2C 10k
CC VDD N_Q2C 1p
XQ3 VDD N_Q2C OUT 0 sky130_fd_pr__npn_05v5_W1p00L1p00
XQB2 OUT N_BIAS GND 0 sky130_fd_pr__npn_05v5_W1p00L1p00
XQNLB N_QNLB N_QNLB N_Q2B 0 sky130_fd_pr__npn_05v5_W1p00L1p00
RNLB N_QNLB OUT 10k
RFMB N_Q2B OUT 10k

.control
set filetype=ascii

op
let vdd_current = abs(i(VVDD))
let power_dc = vdd_current * 1.8
print power_dc

ac dec 100 1 10g
let vout_mag = vm(OUT)
let gain_db = db(vout_mag)
let dc_gain_db = gain_db[0]
print dc_gain_db

if dc_gain_db > 0
    meas ac ugbw WHEN gain_db=0 CROSS=1
end

quit
.endc

.end
