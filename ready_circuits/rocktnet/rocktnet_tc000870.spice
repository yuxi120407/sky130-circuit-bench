* Testcase 000870 — Full Analysis (sky130 tt corner)
* SKY130 model header — replaces the ideal level-1 .model cards
* Ships with the demo; the paths point at the local sky130 PDK checkout.
* NOTE: libs.tech/ngspice/all.spice sets ".option scale=1.0u", so every
* instance L/W below is written in microns WITHOUT a "u" suffix.
.param mc_mm_switch=0
.param mc_pr_switch=0
.include /home/idies/workspace/Temporary/xyu1/scratch/skywater-pdk-libs-sky130_fd_pr/models/corners/tt.spice
.include /home/idies/workspace/Temporary/xyu1/scratch/skywater-pdk-libs-sky130_fd_pr/models/r+c/res_typical__cap_typical.spice
.include /home/idies/workspace/Temporary/xyu1/scratch/skywater-pdk-libs-sky130_fd_pr/models/r+c/res_typical__cap_typical__lin.spice
.include /home/idies/workspace/Temporary/xyu1/scratch/skywater-pdk-libs-sky130_fd_pr/models/corners/tt/specialized_cells.spice
.model DIDEAL D   is=1e-14 n=1
.options reltol=1e-3 itl1=500 itl2=100

* Sources
VVDD VDD 0 1.8
VLABEL_NET_0 LABEL_NET_0 0 DC 0.9 AC 0.5

* Circuit
XMP1 N6 LABEL_NET_0 N12 VDD sky130_fd_pr__pfet_01v8 l=0.5 w=5
XMP9 N6 N5 VDD VDD sky130_fd_pr__pfet_01v8 l=0.5 w=5
XMN10 N1 DN GND GND sky130_fd_pr__nfet_01v8 l=0.5 w=5
XMN4 N7 N3 GND GND sky130_fd_pr__nfet_01v8 l=0.5 w=5
XMP3 OUT N6 N0 VDD sky130_fd_pr__pfet_01v8 l=0.5 w=5
XM6 N11 VDD GND GND sky130_fd_pr__nfet_01v8 l=0.5 w=5
XMN7 N13 REF_DN GND GND sky130_fd_pr__nfet_01v8 l=0.5 w=5
XMN2 N0 UP_B GND GND sky130_fd_pr__nfet_01v8 l=0.5 w=5
XMN6 X N3 N13 GND sky130_fd_pr__nfet_01v8 l=0.5 w=5
XMP5 N10 REF_UP_B VDD VDD sky130_fd_pr__pfet_01v8 l=0.5 w=5
XMP2 N0 UP_B VDD VDD sky130_fd_pr__pfet_01v8 l=0.5 w=5
XMP6 X N6 N10 VDD sky130_fd_pr__pfet_01v8 l=0.5 w=5
XMN8 N5 X N7 GND sky130_fd_pr__nfet_01v8 l=0.5 w=5
XMN9 N6 V0_9 N7 GND sky130_fd_pr__nfet_01v8 l=0.5 w=5
XMN1 N3 N3 N11 GND sky130_fd_pr__nfet_01v8 l=0.5 w=5
XM16 N12 GND VDD VDD sky130_fd_pr__pfet_01v8 l=0.5 w=5
XMP4 N1 DN VDD VDD sky130_fd_pr__pfet_01v8 l=0.5 w=5
XMN5 N10 REF_UP_B GND GND sky130_fd_pr__nfet_01v8 l=0.5 w=5
I1 N6 GND 1u
XMN3 OUT N3 N1 GND sky130_fd_pr__nfet_01v8 l=0.5 w=5
XMP7 N13 REF_DN VDD VDD sky130_fd_pr__pfet_01v8 l=0.5 w=5
I2 VDD N3 1u
R1 REF X 10k
XMP8 N5 N5 VDD VDD sky130_fd_pr__pfet_01v8 l=0.5 w=5
C1 REF GND 1p
C2 N6 N6 1p
C3 N3 GND 1p

.control
set filetype=ascii

op
let vdd_current = abs(i(VVDD))
let power_dc = vdd_current * 1.8
print power_dc

ac dec 100 1 10g
let vout_mag = vm(OUT)
let gain_db = db(vout_mag)
let dc_gain_db = gain_db[0]
print dc_gain_db

if dc_gain_db > 0
    meas ac ugbw WHEN gain_db=0 CROSS=1
end

quit
.endc

.end
