* Testcase 000397 — Full Analysis (sky130 tt corner)
* SKY130 model header — replaces the ideal level-1 .model cards
* Ships with the demo; the paths point at the local sky130 PDK checkout.
* NOTE: libs.tech/ngspice/all.spice sets ".option scale=1.0u", so every
* instance L/W below is written in microns WITHOUT a "u" suffix.
.param mc_mm_switch=0
.param mc_pr_switch=0
.include /home/idies/workspace/Temporary/xyu1/scratch/skywater-pdk-libs-sky130_fd_pr/models/corners/tt.spice
.include /home/idies/workspace/Temporary/xyu1/scratch/skywater-pdk-libs-sky130_fd_pr/models/r+c/res_typical__cap_typical.spice
.include /home/idies/workspace/Temporary/xyu1/scratch/skywater-pdk-libs-sky130_fd_pr/models/r+c/res_typical__cap_typical__lin.spice
.include /home/idies/workspace/Temporary/xyu1/scratch/skywater-pdk-libs-sky130_fd_pr/models/corners/tt/specialized_cells.spice
.model DIDEAL D   is=1e-14 n=1
.options reltol=1e-3 itl1=500 itl2=100

* Sources
VVDD VDD 0 1.8
VVIN_PLUS VIN_PLUS 0 DC 0.9 AC 1 SIN(0.9 0.1 1MEG 0 0)
VVREF_PLUS VREF_PLUS 0 0.9
VVIN_MINUS VIN_MINUS 0 DC 0.9 AC 1 SIN(0.9 0.1 1MEG 0 0)
VVREF_MINUS VREF_MINUS 0 0.9

* Circuit
I1 N2 GND 1u
I2 N1 GND 1u
XM1 N3 VIN_PLUS N1 GND sky130_fd_pr__nfet_01v8 l=0.5 w=5
XM2 N4 VREF_PLUS N1 GND sky130_fd_pr__nfet_01v8 l=0.5 w=5
XM3 N3 VIN_MINUS N2 GND sky130_fd_pr__nfet_01v8 l=0.5 w=5
XM4 N4 VREF_MINUS N2 GND sky130_fd_pr__nfet_01v8 l=0.5 w=5
XM5 N3 N4 VDD VDD sky130_fd_pr__pfet_01v8 l=0.5 w=5
XM6 N4 N4 VDD VDD sky130_fd_pr__pfet_01v8 l=0.5 w=5
XM7 N5 N4 VDD VDD sky130_fd_pr__pfet_01v8 l=0.5 w=5
XM8 N6 N3 VDD VDD sky130_fd_pr__pfet_01v8 l=0.5 w=5
XM9 N5 N6 VDD VDD sky130_fd_pr__pfet_01v8 l=0.5 w=5
XM10 N6 N5 VDD VDD sky130_fd_pr__pfet_01v8 l=0.5 w=5
XM11 N7 CLKB N5 VDD sky130_fd_pr__pfet_01v8 l=0.5 w=5
XM12 N8 CLKB N6 VDD sky130_fd_pr__pfet_01v8 l=0.5 w=5
XM13 N7 N8 GND GND sky130_fd_pr__nfet_01v8 l=0.5 w=5
XM14 N7 CLKB GND GND sky130_fd_pr__nfet_01v8 l=0.5 w=5
XM15 N8 N7 GND GND sky130_fd_pr__nfet_01v8 l=0.5 w=5
XM16 N8 CLKB GND GND sky130_fd_pr__nfet_01v8 l=0.5 w=5
XM17 DOUT_PLUS N8 GND GND sky130_fd_pr__nfet_01v8 l=0.5 w=5
XM18 DOUT_PLUS DOUT_MINUS GND GND sky130_fd_pr__nfet_01v8 l=0.5 w=5
XM19 DOUT_MINUS DOUT_PLUS GND GND sky130_fd_pr__nfet_01v8 l=0.5 w=5
XM20 DOUT_MINUS N7 GND GND sky130_fd_pr__nfet_01v8 l=0.5 w=5
XM21 DOUT_PLUS DOUT_MINUS VDD VDD sky130_fd_pr__pfet_01v8 l=0.5 w=5
XM22 DOUT_MINUS DOUT_PLUS VDD VDD sky130_fd_pr__pfet_01v8 l=0.5 w=5

.control
set filetype=ascii

op
let vdd_current = abs(i(VVDD))
let power_dc = vdd_current * 1.8
print power_dc

print all

quit
.endc

.end
