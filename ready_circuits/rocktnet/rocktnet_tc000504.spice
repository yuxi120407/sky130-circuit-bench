* Testcase 000504 — Full Analysis (sky130 tt corner)
* SKY130 model header — replaces the ideal level-1 .model cards
* Ships with the demo; the paths point at the local sky130 PDK checkout.
* NOTE: libs.tech/ngspice/all.spice sets ".option scale=1.0u", so every
* instance L/W below is written in microns WITHOUT a "u" suffix.
.param mc_mm_switch=0
.param mc_pr_switch=0
.include /home/idies/workspace/Temporary/xyu1/scratch/skywater-pdk-libs-sky130_fd_pr/models/corners/tt.spice
.include /home/idies/workspace/Temporary/xyu1/scratch/skywater-pdk-libs-sky130_fd_pr/models/r+c/res_typical__cap_typical.spice
.include /home/idies/workspace/Temporary/xyu1/scratch/skywater-pdk-libs-sky130_fd_pr/models/r+c/res_typical__cap_typical__lin.spice
.include /home/idies/workspace/Temporary/xyu1/scratch/skywater-pdk-libs-sky130_fd_pr/models/corners/tt/specialized_cells.spice
.model DIDEAL D   is=1e-14 n=1
.options reltol=1e-3 itl1=500 itl2=100

* Sources
VVDD VDD 0 1.8
VIN_PLUS IN_PLUS 0 DC 0.9 AC 1 SIN(0.9 0.1 1MEG 0 0)
VIN_MINUS IN_MINUS 0 DC 0.9 AC 1 SIN(0.9 0.1 1MEG 0 0)
VVB VB 0 0.9900000000000001

* Circuit
XM15 OUT N3 GND GND sky130_fd_pr__nfet_01v8 l=0.5 w=5
XM7 N5 IN_PLUS GND GND sky130_fd_pr__nfet_01v8 l=0.5 w=5
XM5 IN_MINUS IN_PLUS GND GND sky130_fd_pr__nfet_01v8 l=0.5 w=5
XM8 N0 IN_MINUS GND GND sky130_fd_pr__nfet_01v8 l=0.5 w=5
XM3 IN_MINUS IN_MINUS GND GND sky130_fd_pr__nfet_01v8 l=0.5 w=5
XM13 N3 N5 GND GND sky130_fd_pr__nfet_01v8 l=0.5 w=5
XM11 VB VB VDD VDD sky130_fd_pr__pfet_01v8 l=0.5 w=5
XM10 N5 N0 VDD VDD sky130_fd_pr__pfet_01v8 l=0.5 w=5
XM4 IN_PLUS IN_PLUS GND GND sky130_fd_pr__nfet_01v8 l=0.5 w=5
XM1 IN_MINUS IN_MINUS VB VDD sky130_fd_pr__pfet_01v8 l=0.5 w=5
XM2 IN_PLUS IN_PLUS VB VDD sky130_fd_pr__pfet_01v8 l=0.5 w=5
XM9 N0 N0 VDD VDD sky130_fd_pr__pfet_01v8 l=0.5 w=5
XM6 IN_PLUS IN_MINUS GND GND sky130_fd_pr__nfet_01v8 l=0.5 w=5
XM14 OUT N3 VDD VDD sky130_fd_pr__pfet_01v8 l=0.5 w=5
XM12 N3 N5 VDD VDD sky130_fd_pr__pfet_01v8 l=0.5 w=5

.control
set filetype=ascii

op
let vdd_current = abs(i(VVDD))
let power_dc = vdd_current * 1.8
print power_dc

ac dec 100 1 10g
let vout_mag = vm(OUT)
let gain_db = db(vout_mag)
let dc_gain_db = gain_db[0]
print dc_gain_db

if dc_gain_db > 0
    meas ac ugbw WHEN gain_db=0 CROSS=1
end

quit
.endc

.end
