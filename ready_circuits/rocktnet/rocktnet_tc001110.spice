* Testcase 001110 — Full Analysis (sky130 tt corner)
* SKY130 model header — replaces the ideal level-1 .model cards
* Ships with the demo; the paths point at the local sky130 PDK checkout.
* NOTE: libs.tech/ngspice/all.spice sets ".option scale=1.0u", so every
* instance L/W below is written in microns WITHOUT a "u" suffix.
.param mc_mm_switch=0
.param mc_pr_switch=0
.include /home/idies/workspace/Temporary/xyu1/scratch/skywater-pdk-libs-sky130_fd_pr/models/corners/tt.spice
.include /home/idies/workspace/Temporary/xyu1/scratch/skywater-pdk-libs-sky130_fd_pr/models/r+c/res_typical__cap_typical.spice
.include /home/idies/workspace/Temporary/xyu1/scratch/skywater-pdk-libs-sky130_fd_pr/models/r+c/res_typical__cap_typical__lin.spice
.include /home/idies/workspace/Temporary/xyu1/scratch/skywater-pdk-libs-sky130_fd_pr/models/corners/tt/specialized_cells.spice
.model DIDEAL D   is=1e-14 n=1
.options reltol=1e-3 itl1=500 itl2=100

* Sources
VVDD VDD 0 1.8
VLABEL_NET_0 LABEL_NET_0 0 DC 0.9 AC 0.5
VLABEL_NET_2 LABEL_NET_2 0 DC 0.9 AC -0.5
VLABEL_NET_3 LABEL_NET_3 0 0.9
VLABEL_NET_4 LABEL_NET_4 0 0.9

* Circuit
XQ1 N5 N2 N0 0 sky130_fd_pr__npn_05v5_W1p00L1p00
XQ2 N5 LABEL_NET_0 N0 0 sky130_fd_pr__npn_05v5_W1p00L1p00
XQ3 N5 N2 N1 0 sky130_fd_pr__npn_05v5_W1p00L1p00
XQ4 N5 LABEL_NET_2 N1 0 sky130_fd_pr__npn_05v5_W1p00L1p00
XM1 N0 LABEL_NET_3 GND GND sky130_fd_pr__nfet_01v8 l=0.5 w=5
XM2 N0 N3 N7 VDD sky130_fd_pr__pfet_01v8 l=0.5 w=5
XM3 N1 N3 N6 VDD sky130_fd_pr__pfet_01v8 l=0.5 w=5
C1 N4 N5 1p
C2 N4 N5 1p
R1 N4 N5 10k
R2 N4 N7 10k
R3 N4 N6 10k
XM4 N1 LABEL_NET_4 GND GND sky130_fd_pr__nfet_01v8 l=0.5 w=5
R4 N4 N5 10k

.control
set filetype=ascii

op
let power_dc = abs(i(VVDD)) * 1.8
print power_dc

ac dec 100 1 10g
let vout_mag = vm(N0)
let gain_db = db(vout_mag)
let dc_gain_db = gain_db[0]
print dc_gain_db

if dc_gain_db > 0
    meas ac ugbw WHEN gain_db=0 CROSS=1
    print ugbw
end

quit
.endc

.end
