* Testcase 000527 — Full Analysis (sky130 tt corner)
* SKY130 model header — replaces the ideal level-1 .model cards
* Ships with the demo; the paths point at the local sky130 PDK checkout.
* NOTE: libs.tech/ngspice/all.spice sets ".option scale=1.0u", so every
* instance L/W below is written in microns WITHOUT a "u" suffix.
.param mc_mm_switch=0
.param mc_pr_switch=0
.include /home/idies/workspace/Temporary/xyu1/scratch/skywater-pdk-libs-sky130_fd_pr/models/corners/tt.spice
.include /home/idies/workspace/Temporary/xyu1/scratch/skywater-pdk-libs-sky130_fd_pr/models/r+c/res_typical__cap_typical.spice
.include /home/idies/workspace/Temporary/xyu1/scratch/skywater-pdk-libs-sky130_fd_pr/models/r+c/res_typical__cap_typical__lin.spice
.include /home/idies/workspace/Temporary/xyu1/scratch/skywater-pdk-libs-sky130_fd_pr/models/corners/tt/specialized_cells.spice
.model DIDEAL D   is=1e-14 n=1
.options reltol=1e-3 itl1=500 itl2=100

* Sources
VVDD VDD 0 1.8
VLABEL_NET_2 LABEL_NET_2 0 DC 0.9 AC 0.5

* Circuit
XM1 N6 N11 GND GND sky130_fd_pr__nfet_01v8 l=0.5 w=5
R1 VDD N6 10k
R2 VDD N10 10k
R3 VDD N7 10k
R4 VDD N5 10k
XM2 N0 VDD GND GND sky130_fd_pr__nfet_01v8 l=0.5 w=5
XM3 N4 VDD GND GND sky130_fd_pr__nfet_01v8 l=0.5 w=5
XM4 IFY VDD N4 GND sky130_fd_pr__nfet_01v8 l=0.5 w=5
R5 VDD IFY 10k
XM5 N7 N9 GND GND sky130_fd_pr__nfet_01v8 l=0.5 w=5
XM6 N5 LOY GND GND sky130_fd_pr__nfet_01v8 l=0.5 w=5
R6 VDD IFX 10k
XM7 N10 VDD GND GND sky130_fd_pr__nfet_01v8 l=0.5 w=5
XM8 IFX VDD N0 GND sky130_fd_pr__nfet_01v8 l=0.5 w=5
XM9 IFX LABEL_NET_2 N4 GND sky130_fd_pr__nfet_01v8 l=0.5 w=5
XM10 IFY N8 N0 GND sky130_fd_pr__nfet_01v8 l=0.5 w=5
C1 N7 N8 1p
C2 IFY IFX 1p
C3 N5 N11 1p
C4 N9 N10 1p
C5 VDD N6 1p

.control
set filetype=ascii

op
let power_dc = abs(i(VVDD)) * 1.8
print power_dc

ac dec 100 1 10g
let vout_mag = vm(IFX)
let gain_db = db(vout_mag)
let dc_gain_db = gain_db[0]
print dc_gain_db

if dc_gain_db > 0
    meas ac ugbw WHEN gain_db=0 CROSS=1
    print ugbw
end

quit
.endc

.end
