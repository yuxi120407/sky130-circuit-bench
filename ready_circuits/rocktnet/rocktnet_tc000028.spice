* Testcase 000028 — Full Analysis (sky130 tt corner)
* SKY130 model header — replaces the ideal level-1 .model cards
* Ships with the demo; the paths point at the local sky130 PDK checkout.
* NOTE: libs.tech/ngspice/all.spice sets ".option scale=1.0u", so every
* instance L/W below is written in microns WITHOUT a "u" suffix.
.param mc_mm_switch=0
.param mc_pr_switch=0
.include /home/idies/workspace/Temporary/xyu1/scratch/skywater-pdk-libs-sky130_fd_pr/models/corners/tt.spice
.include /home/idies/workspace/Temporary/xyu1/scratch/skywater-pdk-libs-sky130_fd_pr/models/r+c/res_typical__cap_typical.spice
.include /home/idies/workspace/Temporary/xyu1/scratch/skywater-pdk-libs-sky130_fd_pr/models/r+c/res_typical__cap_typical__lin.spice
.include /home/idies/workspace/Temporary/xyu1/scratch/skywater-pdk-libs-sky130_fd_pr/models/corners/tt/specialized_cells.spice
.model DIDEAL D   is=1e-14 n=1
.options reltol=1e-3 itl1=500 itl2=100

* Sources
VLABEL_NET_0 LABEL_NET_0 0 0.9
VLABEL_NET_1 LABEL_NET_1 0 0.9

* Circuit
XM1 N7 N8 N2 GND sky130_fd_pr__nfet_01v8 l=0.5 w=5
XM2 N3 N9 N5 GND sky130_fd_pr__nfet_01v8 l=0.5 w=5
XM3 N7 N1 N2 GND sky130_fd_pr__nfet_01v8 l=0.5 w=5
XQ1 N2 N10 N4 0 sky130_fd_pr__npn_05v5_W1p00L1p00
XQ2 N2 LABEL_NET_0 N3 0 sky130_fd_pr__npn_05v5_W1p00L1p00
XQ3 N2 N0 N3 0 sky130_fd_pr__npn_05v5_W1p00L1p00
R1 N7 N8 10k
XM4 N4 N6 N5 N5 sky130_fd_pr__nfet_01v8 l=0.5 w=5
R2 N1 N7 10k
XQ4 N2 N3 N4 0 sky130_fd_pr__npn_05v5_W1p00L1p00
I1 N5 LABEL_NET_1 1u

.control
set filetype=ascii

op
let power_dc = abs(i(VLABEL_NET_0)) * 1.8
print power_dc
let dc_voltage = v(N1)
print dc_voltage

quit
.endc

.end
