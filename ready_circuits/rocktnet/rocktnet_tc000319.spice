* Testcase 000319 — Full Analysis (sky130 tt corner)
* SKY130 model header — replaces the ideal level-1 .model cards
* Ships with the demo; the paths point at the local sky130 PDK checkout.
* NOTE: libs.tech/ngspice/all.spice sets ".option scale=1.0u", so every
* instance L/W below is written in microns WITHOUT a "u" suffix.
.param mc_mm_switch=0
.param mc_pr_switch=0
.include /home/idies/workspace/Temporary/xyu1/scratch/skywater-pdk-libs-sky130_fd_pr/models/corners/tt.spice
.include /home/idies/workspace/Temporary/xyu1/scratch/skywater-pdk-libs-sky130_fd_pr/models/r+c/res_typical__cap_typical.spice
.include /home/idies/workspace/Temporary/xyu1/scratch/skywater-pdk-libs-sky130_fd_pr/models/r+c/res_typical__cap_typical__lin.spice
.include /home/idies/workspace/Temporary/xyu1/scratch/skywater-pdk-libs-sky130_fd_pr/models/corners/tt/specialized_cells.spice
.model DIDEAL D   is=1e-14 n=1
.options reltol=1e-3 itl1=500 itl2=100

* Sources
VVDD VDD 0 1.8
VLABEL_NET_0 LABEL_NET_0 0 DC 0.9 AC 0.5
VLABEL_NET_1 LABEL_NET_1 0 DC 0.9 AC 1

* Circuit
XM1 N5 N6 N4 VDD sky130_fd_pr__pfet_01v8 l=0.5 w=5
XM2 N0 LABEL_NET_0 N3 GND sky130_fd_pr__nfet_01v8 l=0.5 w=5
L1 N13 GND 10n
R1 VDD N0 10k
I1 VDD N4 1u
L2 N2 N12 10n
C1 N1 N6 1p
XM3 N5 N8 N12 GND sky130_fd_pr__nfet_01v8 l=0.5 w=5
C2 N9 N10 1p
XM4 N3 N7 N12 GND sky130_fd_pr__nfet_01v8 l=0.5 w=5
R2 VDD N0 10k
XM5 N0 N11 N3 GND sky130_fd_pr__nfet_01v8 l=0.5 w=5
XM6 N0 N11 N5 GND sky130_fd_pr__nfet_01v8 l=0.5 w=5
XM7 N0 LABEL_NET_1 N5 GND sky130_fd_pr__nfet_01v8 l=0.5 w=5
C3 N5 N13 1p
C4 N1 N8 1p
XM8 N3 N9 N4 VDD sky130_fd_pr__pfet_01v8 l=0.5 w=5
C5 VDD N0 1p
C6 N7 N10 1p
C7 N3 N13 1p
C8 N2 N12 1p
C9 VDD N0 1p

.control
set filetype=ascii

op
let power_dc = abs(i(VVDD)) * 1.8
print power_dc

ac dec 100 1 10g
let gain_N5 = db(vm(N5))
let gain_N6 = db(vm(N6))
let gain_N8 = db(vm(N8))
let gain_N9 = db(vm(N9))
let gain_N4 = db(vm(N4))
meas ac max_gain_N5 MAX gain_N5
meas ac max_gain_N6 MAX gain_N6
meas ac max_gain_N8 MAX gain_N8
meas ac max_gain_N9 MAX gain_N9
meas ac max_gain_N4 MAX gain_N4

* Use first probe node for standard metrics
let gain_db = db(vm(N5))
meas ac dc_gain_db FIND gain_db AT=1
meas ac ugbw WHEN gain_db=0 CROSS=1
let vout_dc = v(N5)

print dc_gain_db ugbw vout_dc gain_N5 gain_N6 gain_N8 gain_N9 gain_N4

quit
.endc

.end
