* Testcase 000999 — Full Analysis (sky130 tt corner)
* SKY130 model header — replaces the ideal level-1 .model cards
* Ships with the demo; the paths point at the local sky130 PDK checkout.
* NOTE: libs.tech/ngspice/all.spice sets ".option scale=1.0u", so every
* instance L/W below is written in microns WITHOUT a "u" suffix.
.param mc_mm_switch=0
.param mc_pr_switch=0
.include /home/idies/workspace/Temporary/xyu1/scratch/skywater-pdk-libs-sky130_fd_pr/models/corners/tt.spice
.include /home/idies/workspace/Temporary/xyu1/scratch/skywater-pdk-libs-sky130_fd_pr/models/r+c/res_typical__cap_typical.spice
.include /home/idies/workspace/Temporary/xyu1/scratch/skywater-pdk-libs-sky130_fd_pr/models/r+c/res_typical__cap_typical__lin.spice
.include /home/idies/workspace/Temporary/xyu1/scratch/skywater-pdk-libs-sky130_fd_pr/models/corners/tt/specialized_cells.spice
.model DIDEAL D   is=1e-14 n=1
.options reltol=1e-3 itl1=500 itl2=100

* Sources
VVDD VDD 0 1.8
VVBN1 VBN1 0 0.54
VVBCP VBCP 0 0.9900000000000001
VVBP1 VBP1 0 0.9900000000000001
VVBCN VBCN 0 0.54
VVCM1 VCM1 0 0.9
VVCM2 VCM2 0 0.9
VVIN VIN 0 DC 0.9 AC 1 SIN(0.9 0.1 1MEG 0 0)

* Circuit
XM1_UNLABELLED N4 VBN1 GND GND sky130_fd_pr__nfet_01v8 l=0.5 w=5
XM2_UNLABELLED VCP VBCP N3 VDD sky130_fd_pr__pfet_01v8 l=0.5 w=5
XM3_UNLABELLED VCN VBCP N1 VDD sky130_fd_pr__pfet_01v8 l=0.5 w=5
XM7 N4 VCP N0 VDD sky130_fd_pr__pfet_01v8 l=0.5 w=5
XM5_UNLABELLED N1 VBP1 N12 VDD sky130_fd_pr__pfet_01v8 l=0.5 w=5
XM6 VCN VBCN N9 GND sky130_fd_pr__nfet_01v8 l=0.5 w=5
XM7_UNLABELLED N0 N17 N12 VDD sky130_fd_pr__pfet_01v8 l=0.5 w=5
XM8_UNLABELLED N3 N17 N12 VDD sky130_fd_pr__pfet_01v8 l=0.5 w=5
XM9_UNLABELLED N9 VCM1 GND GND sky130_fd_pr__nfet_01v8 l=0.5 w=5
XM10 N4 VCM2 GND GND sky130_fd_pr__nfet_01v8 l=0.5 w=5
XM5 VCP VBCN N5 GND sky130_fd_pr__nfet_01v8 l=0.5 w=5
XM12 N5 VCM1 GND GND sky130_fd_pr__nfet_01v8 l=0.5 w=5
XM8 N4 VCN N0 VDD sky130_fd_pr__pfet_01v8 l=0.5 w=5
XM9 N4 VCM2 GND GND sky130_fd_pr__nfet_01v8 l=0.5 w=5
XM15 N4 N6 GND GND sky130_fd_pr__nfet_01v8 l=0.5 w=5
XM16 N8 VBP1 N12 VDD sky130_fd_pr__pfet_01v8 l=0.5 w=5
XM2 N9 VIP N4 GND sky130_fd_pr__nfet_01v8 l=0.5 w=5
XM1 N5 VIN N4 GND sky130_fd_pr__nfet_01v8 l=0.5 w=5
XM19 N4 N2 GND GND sky130_fd_pr__nfet_01v8 l=0.5 w=5
XM4 N9 VIP N8 VDD sky130_fd_pr__pfet_01v8 l=0.5 w=5
XM3 N5 VIN N8 VDD sky130_fd_pr__pfet_01v8 l=0.5 w=5
C2 N6 VCN 1p
C1 N2 VCP 1p
C3 N3 N4 1p
C4 N1 N4 1p

.control
set filetype=ascii

op
let vdd_current = abs(i(VVDD))
let power_dc = vdd_current * 1.8
print power_dc

print all

let vout_dc = v(N4)
print vout_dc
let vout_dc = v(VCN)
print vout_dc
quit
.endc

.end
