* Testcase 000787 — Full Analysis (sky130 tt corner)
* SKY130 model header — replaces the ideal level-1 .model cards
* Ships with the demo; the paths point at the local sky130 PDK checkout.
* NOTE: libs.tech/ngspice/all.spice sets ".option scale=1.0u", so every
* instance L/W below is written in microns WITHOUT a "u" suffix.
.param mc_mm_switch=0
.param mc_pr_switch=0
.include /home/idies/workspace/Temporary/xyu1/scratch/skywater-pdk-libs-sky130_fd_pr/models/corners/tt.spice
.include /home/idies/workspace/Temporary/xyu1/scratch/skywater-pdk-libs-sky130_fd_pr/models/r+c/res_typical__cap_typical.spice
.include /home/idies/workspace/Temporary/xyu1/scratch/skywater-pdk-libs-sky130_fd_pr/models/r+c/res_typical__cap_typical__lin.spice
.include /home/idies/workspace/Temporary/xyu1/scratch/skywater-pdk-libs-sky130_fd_pr/models/corners/tt/specialized_cells.spice
.model DIDEAL D   is=1e-14 n=1
.options reltol=1e-3 itl1=500 itl2=100

* Sources
VVDD VDD 0 1.8
VVB1 VB1 0 0.9900000000000001
VVIN VIN 0 DC 0.9 AC 1 SIN(0.9 0.1 1MEG 0 0)
VVB2 VB2 0 0.54

* Circuit
XM0 N_TAIL VB1 VDD VDD sky130_fd_pr__pfet_01v8 l=0.5 w=5
XM1 N_FOLD1 VIP N_TAIL VDD sky130_fd_pr__pfet_01v8 l=0.5 w=5
XM2 N_FOLD2 VIN N_TAIL VDD sky130_fd_pr__pfet_01v8 l=0.5 w=5
XM3 N_FOLD1 N_FOLD1 GND GND sky130_fd_pr__nfet_01v8 l=0.5 w=5
XM4 N_FOLD2 N_FOLD1 GND GND sky130_fd_pr__nfet_01v8 l=0.5 w=5
XM5 N_FOLD1 N_FOLD1 GND GND sky130_fd_pr__nfet_01v8 l=0.5 w=5
XM6 N_FOLD2 N_FOLD1 GND GND sky130_fd_pr__nfet_01v8 l=0.5 w=5
XM7 N_CASC1 VB2 N_FOLD1 GND sky130_fd_pr__nfet_01v8 l=0.5 w=5
XM8 N_CASC2 VB2 N_FOLD2 GND sky130_fd_pr__nfet_01v8 l=0.5 w=5
XM9 N_CASC1 VB1 VDD VDD sky130_fd_pr__pfet_01v8 l=0.5 w=5
XM10 N_CASC2 VB1 VDD VDD sky130_fd_pr__pfet_01v8 l=0.5 w=5
XM11 VOUT N_CASC2 GND GND sky130_fd_pr__nfet_01v8 l=0.5 w=5
XM12 VOUT VB1 VDD VDD sky130_fd_pr__pfet_01v8 l=0.5 w=5
CC N_CASC2 VOUT 1p

.control
set filetype=ascii

op
let vdd_current = abs(i(VVDD))
let power_dc = vdd_current * 1.8
print power_dc

ac dec 100 1 10g
let vout_mag = vm(VOUT)
let gain_db = db(vout_mag)
let dc_gain_db = gain_db[0]
print dc_gain_db

if dc_gain_db > 0
    meas ac ugbw WHEN gain_db=0 CROSS=1
end

quit
.endc

.end
