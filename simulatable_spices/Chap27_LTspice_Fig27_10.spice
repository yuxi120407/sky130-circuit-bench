* Circuit: Chap27_LTspice/Fig27_10
.lib ${SKY130_PDK} tt

VDD VDD 0 5
xmsu3 N001 Vbiasn 0 0 sky130_fd_pr__nfet_01v8 w=1.47 l=2
xm31 n1 n1 VDD VDD sky130_fd_pr__pfet_01v8 w=1.47 l=1
xm41 n2 n2 VDD VDD sky130_fd_pr__pfet_01v8 w=1.47 l=1
xm2 n2 vm N001 0 sky130_fd_pr__nfet_01v8 w=1.47 l=1
xm1 n1 vp N001 0 sky130_fd_pr__nfet_01v8 w=1.47 l=1
X_U1 Vbiasn Vbiasp VDD 0 Fig_20_15
Vp vp 0 2.5
Vm vm 0 2.5
xm3 vop n1 VDD VDD sky130_fd_pr__pfet_01v8 w=1.47 l=1
xm4 vom n2 VDD VDD sky130_fd_pr__pfet_01v8 w=1.47 l=1
xm5 vop vop N006 0 sky130_fd_pr__nfet_01v8 w=1.47 l=1
xm6 vop vom N006 0 sky130_fd_pr__nfet_01v8 w=1.47 l=1
xm7 vom vop N006 0 sky130_fd_pr__nfet_01v8 w=1.47 l=1
xm8 vom vom N006 0 sky130_fd_pr__nfet_01v8 w=1.47 l=1
xmsu1 N006 N006 0 0 sky130_fd_pr__nfet_01v8 w=1.47 l=10
xm9 N002 Vbiasp VDD VDD sky130_fd_pr__pfet_01v8 w=1.47 l=1
xm10 N005 vom N002 VDD sky130_fd_pr__pfet_01v8 w=1.47 l=1
xm11 N003 vop N002 VDD sky130_fd_pr__pfet_01v8 w=1.47 l=1
xm12 N005 N005 0 0 sky130_fd_pr__nfet_01v8 w=1.47 l=1
xm13 N003 N005 0 0 sky130_fd_pr__nfet_01v8 w=1.47 l=1
xm14 Out N003 VDD VDD sky130_fd_pr__pfet_01v8 w=1.47 l=1
xm15 Out N003 0 0 sky130_fd_pr__nfet_01v8 w=1.47 l=1
xm16 N008 N008 0 0 sky130_fd_pr__nfet_01v8 w=1.47 l=1
xm17 n2 N007 0 0 sky130_fd_pr__nfet_01v8 w=1.47 l=1
xm18 N007 N007 0 0 sky130_fd_pr__nfet_01v8 w=1.47 l=1
xm19 n1 N008 0 0 sky130_fd_pr__nfet_01v8 w=1.47 l=1
xm20 N004 Vbiasp VDD VDD sky130_fd_pr__pfet_01v8 w=1.47 l=2
xm21 N007 vp N004 VDD sky130_fd_pr__pfet_01v8 w=1.47 l=1
xm22 N008 vm N004 VDD sky130_fd_pr__pfet_01v8 w=1.47 l=1
.subckt Fig_20_15 Vbiasn Vbiasp VDD GND
  xmsu2 N001 N001 VDD VDD sky130_fd_pr__pfet_01v8 w=10 l=20
  xmsu1 N001 Vbiasn 0 0 sky130_fd_pr__nfet_01v8 w=10 l=2
  xmsu3 VDD N001 Vbiasn 0 sky130_fd_pr__nfet_01v8 w=10 l=1
  xm3 Vbiasn Vbiasp VDD VDD sky130_fd_pr__pfet_01v8 w=30 l=2
  xm4 Vbiasp Vbiasp VDD VDD sky130_fd_pr__pfet_01v8 w=30 l=2
  xm1 Vbiasn Vbiasn 0 0 sky130_fd_pr__nfet_01v8 w=10 l=2
  xm2 Vbiasp Vbiasn N002 0 sky130_fd_pr__nfet_01v8 w=40 l=2
  R1 N002 GND 6.5k
.ends Fig_20_15

.control
dc Vp 0 5.0 0.01

let vout_deriv = deriv(v(Out))
let gain_linear = abs(vout_deriv)
let gain_db = db(gain_linear)
meas dc dc_gain_db MAX gain_db

let vdd_current = abs(i(VDD))
let power_dc = mean(vdd_current) * 5.0
print dc_gain_db power_dc

quit
.endc

.end
