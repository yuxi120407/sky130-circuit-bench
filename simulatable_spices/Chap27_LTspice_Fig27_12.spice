* CIRCUIT: Chap27_LTspice_Fig27_12
* YAML: /home/idies/workspace/Storage/xyu1/persistent/ALIGN-public/simple_circuit_5/OpenManus/autosizer_plus/circuits_yaml_generated/Chap27_LTspice__Fig27_12.yaml
* Variables: ['W_nfet_g0', 'W_pfet_g1', 'W_pfet_g2']
* Trial values (midpoint): [1.47, 1.47, 1.47]
* Metrics: ['avg_power', 'vout_swing', 'rise_time', 'fall_time', 'fom']
* Class: mosfet_analog_tran
* FOM: 0.0
* FIXED: node rename {'vout': 'out'}

* Circuit: Chap27_LTspice/Fig27_12
.lib ${SKY130_PDK} tt

VDD VDD 0 5
xmsu3 N001 Vbiasn 0 0 sky130_fd_pr__nfet_01v8 w=1.47 l=2
xm31 n1 n1 VDD VDD sky130_fd_pr__pfet_01v8 w=1.47 l=1
xm41 n2 n2 VDD VDD sky130_fd_pr__pfet_01v8 w=1.47 l=1
xm2 n2 vm N001 0 sky130_fd_pr__nfet_01v8 w=1.47 l=1
xm1 n1 vp N001 0 sky130_fd_pr__nfet_01v8 w=1.47 l=1
X_U1 Vbiasn Vbiasp VDD 0 Fig_20_15
Vp vp 0 PULSE 2.45 2.55 125n 0 0 10n
Vm vm 0 2.5
xm3 vop n1 VDD VDD sky130_fd_pr__pfet_01v8 w=1.47 l=1
xm4 vom n2 VDD VDD sky130_fd_pr__pfet_01v8 w=1.47 l=1
xm5 vop vop N006 0 sky130_fd_pr__nfet_01v8 w=1.47 l=1
xm6 vop vom N006 0 sky130_fd_pr__nfet_01v8 w=1.47 l=1
xm7 vom vop N006 0 sky130_fd_pr__nfet_01v8 w=1.47 l=1
xm8 vom vom N006 0 sky130_fd_pr__nfet_01v8 w=1.47 l=1
xmsu1 N006 N006 0 0 sky130_fd_pr__nfet_01v8 w=1.47 l=10
xm9 N002 Vbiasp VDD VDD sky130_fd_pr__pfet_01v8 w=1.47 l=1
xm10 N005 vom N002 VDD sky130_fd_pr__pfet_01v8 w=1.47 l=1
xm11 N003 vop N002 VDD sky130_fd_pr__pfet_01v8 w=1.47 l=1
xm12 N005 N005 0 0 sky130_fd_pr__nfet_01v8 w=1.47 l=1
xm13 N003 N005 0 0 sky130_fd_pr__nfet_01v8 w=1.47 l=1
xm14 Out N003 VDD VDD sky130_fd_pr__pfet_01v8 w=1.47 l=1
xm15 Out N003 0 0 sky130_fd_pr__nfet_01v8 w=1.47 l=1
xm16 N008 N008 0 0 sky130_fd_pr__nfet_01v8 w=1.47 l=1
xm17 n2 N007 0 0 sky130_fd_pr__nfet_01v8 w=1.47 l=1
xm18 N007 N007 0 0 sky130_fd_pr__nfet_01v8 w=1.47 l=1
xm19 n1 N008 0 0 sky130_fd_pr__nfet_01v8 w=1.47 l=1
xm20 N004 Vbiasp VDD VDD sky130_fd_pr__pfet_01v8 w=1.47 l=2
xm21 N007 vp N004 VDD sky130_fd_pr__pfet_01v8 w=1.47 l=1
xm22 N008 vm N004 VDD sky130_fd_pr__pfet_01v8 w=1.47 l=1
.subckt Fig_20_15 Vbiasn Vbiasp VDD GND
  xmsu2 N001 N001 VDD VDD sky130_fd_pr__pfet_01v8 w=10 l=20
  xmsu1 N001 Vbiasn 0 0 sky130_fd_pr__nfet_01v8 w=10 l=2
  xmsu3 VDD N001 Vbiasn 0 sky130_fd_pr__nfet_01v8 w=10 l=1
  xm3 Vbiasn Vbiasp VDD VDD sky130_fd_pr__pfet_01v8 w=30 l=2
  xm4 Vbiasp Vbiasp VDD VDD sky130_fd_pr__pfet_01v8 w=30 l=2
  xm1 Vbiasn Vbiasn 0 0 sky130_fd_pr__nfet_01v8 w=10 l=2
  xm2 Vbiasp Vbiasn N002 0 sky130_fd_pr__nfet_01v8 w=40 l=2
  R1 N002 GND 6.5k
.ends Fig_20_15

.control
tran 1p 100n

let power = v(VDD) * abs(i(VDD))
let avg_power = mean(power)
print avg_power

meas tran vout_max MAX v(out)
meas tran vout_min MIN v(out)
let vout_swing = vout_max - vout_min
print vout_swing

meas tran rise_time TRIG v(out) VAL='0.1*vout_max' RISE=1 TARG v(out) VAL='0.9*vout_max' RISE=1
meas tran fall_time TRIG v(out) VAL='0.9*vout_max' FALL=1 TARG v(out) VAL='0.1*vout_max' FALL=1
print rise_time fall_time

quit
.endc

.end
