* Circuit: Chap26_LTspice/Fig26_28
.lib ${SKY130_PDK} tt

VDD VDD 0 1
xm4 N001 Vbiasp VDD VDD sky130_fd_pr__pfet_01v8 w=1.47 l=0.15
VCMA VCMA 0 500m
xm6t VCMFB1 VCMFB1 0 0 sky130_fd_pr__nfet_01v8 w=1.47 l=0.15
VCM VCM 0 500m
X_U1 Vbiasn Vbiasp VDD 0 Fig_26_3
xm5 N003 N003 0 0 sky130_fd_pr__nfet_01v8 w=1.47 l=0.15
xm1 N003 VCMA N001 VDD sky130_fd_pr__pfet_01v8 w=1.47 l=0.15
xm2 VCMFB1 VCM N001 VDD sky130_fd_pr__pfet_01v8 w=1.47 l=0.15
xm3 N002 Vbiasp VDD VDD sky130_fd_pr__pfet_01v8 w=1.47 l=0.15
xm6 VCMFB2 N004 0 0 sky130_fd_pr__nfet_01v8 w=1.47 l=0.15
xm7 N004 N004 0 0 sky130_fd_pr__nfet_01v8 w=1.47 l=0.15
xm8 N004 VCMA N002 VDD sky130_fd_pr__pfet_01v8 w=1.47 l=0.15
xm9 VCMFB2 VCM N002 VDD sky130_fd_pr__pfet_01v8 w=1.47 l=0.15
.subckt Fig_26_3 Vbiasn Vbiasp VDD GND
  xmsu2 N002 N002 VDD VDD sky130_fd_pr__pfet_01v8 w=1 l=0.15
  xmsu1 N002 Vbiasn GND 0 sky130_fd_pr__nfet_01v8 w=0.5 l=0.15
  xmsu3 Vbiasp N002 Vbiasn 0 sky130_fd_pr__nfet_01v8 w=1 l=0.15
  xm3 Vbiasn Vbiasp VDD VDD sky130_fd_pr__pfet_01v8 w=1 l=0.15
  xm4 N003 Vbiasp VDD VDD sky130_fd_pr__pfet_01v8 w=1 l=0.15
  xm1 Vbiasn Vbiasn 0 0 sky130_fd_pr__nfet_01v8 w=0.5 l=0.15
  R1 N004 0 4k
  xma4 Vbiasp N001 VDD VDD sky130_fd_pr__pfet_01v8 w=1 l=0.15
  xma3 N001 N001 VDD VDD sky130_fd_pr__pfet_01v8 w=1 l=0.15
  xm5 N001 N003 0 0 sky130_fd_pr__nfet_01v8 w=0.5 l=0.15
  xm7 VDD Vbiasp VDD VDD sky130_fd_pr__pfet_01v8 w=5 l=5
  xm2 Vbiasp Vbiasn 0 0 sky130_fd_pr__nfet_01v8 w=0.5 l=0.15
  xm6 N003 N003 N004 0 sky130_fd_pr__nfet_01v8 w=2 l=0.15
.ends Fig_26_3

.control
op

let vdd_current = abs(i(VDD))
let power_dc = vdd_current * 1.0
print power_dc

* Print all node voltages for diagnosis
print all

quit
.endc

.end
