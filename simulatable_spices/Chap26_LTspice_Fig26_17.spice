* Circuit: Chap26_LTspice/Fig26_17
.lib ${SKY130_PDK} tt

VDD VDD 0 1
xm2 vom N002 N003 0 sky130_fd_pr__nfet_01v8 w=1.47 l=0.15
xm1 vop N001 N003 0 sky130_fd_pr__nfet_01v8 w=1.47 l=0.15
xm4 vom Vbiasp VDD VDD sky130_fd_pr__pfet_01v8 w=1.47 l=0.15
xm3 vop Vbiasp VDD VDD sky130_fd_pr__pfet_01v8 w=1.47 l=0.15
VCM1 N001 0 500m
xm6t N003 VCMFB 0 0 sky130_fd_pr__nfet_01v8 w=1.47 l=0.15
VCM N002 0 500m
X_U1 Vbiasn Vbiasp VDD 0 Fig_26_3
xm5 N003 Vbiasn 0 0 sky130_fd_pr__nfet_01v8 w=1.47 l=0.15
Vcmfb VCMFB 0 1
.subckt Fig_26_3 Vbiasn Vbiasp VDD GND
  xmsu2 N002 N002 VDD VDD sky130_fd_pr__pfet_01v8 w=1 l=0.15
  xmsu1 N002 Vbiasn GND 0 sky130_fd_pr__nfet_01v8 w=0.5 l=0.15
  xmsu3 Vbiasp N002 Vbiasn 0 sky130_fd_pr__nfet_01v8 w=1 l=0.15
  xm3 Vbiasn Vbiasp VDD VDD sky130_fd_pr__pfet_01v8 w=1 l=0.15
  xm4 N003 Vbiasp VDD VDD sky130_fd_pr__pfet_01v8 w=1 l=0.15
  xm1 Vbiasn Vbiasn 0 0 sky130_fd_pr__nfet_01v8 w=0.5 l=0.15
  R1 N004 0 4k
  xma4 Vbiasp N001 VDD VDD sky130_fd_pr__pfet_01v8 w=1 l=0.15
  xma3 N001 N001 VDD VDD sky130_fd_pr__pfet_01v8 w=1 l=0.15
  xm5 N001 N003 0 0 sky130_fd_pr__nfet_01v8 w=0.5 l=0.15
  xm7 VDD Vbiasp VDD VDD sky130_fd_pr__pfet_01v8 w=5 l=5
  xm2 Vbiasp Vbiasn 0 0 sky130_fd_pr__nfet_01v8 w=0.5 l=0.15
  xm6 N003 N003 N004 0 sky130_fd_pr__nfet_01v8 w=2 l=0.15
.ends Fig_26_3

.control
op

let vdd_current = abs(i(VDD))
let power_dc = vdd_current * 1.0
print power_dc

* Print all node voltages for diagnosis
print all

quit
.endc

.end
