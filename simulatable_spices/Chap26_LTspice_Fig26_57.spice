* Circuit: Chap26_LTspice/Fig26_57
.lib ${SKY130_PDK} tt

VDD VDD 0 1
xm2 vomd Vbias1 N011 0 sky130_fd_pr__nfet_01v8 w=1.47 l=0.15
xm3 Vbias1 Vbias2 N003 VDD sky130_fd_pr__pfet_01v8 w=1.47 l=0.15
VCM VCM 0 500m
X_U1 Vbiasn Vbiasp VDD 0 Fig_26_3
xm6 N001 Vbias1 VDD VDD sky130_fd_pr__pfet_01v8 w=1.47 l=0.15
xm9 N003 Vbias1 VDD VDD sky130_fd_pr__pfet_01v8 w=1.47 l=0.15
xm10 Vbias2 Vbias2 VDD VDD sky130_fd_pr__pfet_01v8 w=1.47 l=0.15
xm13 Vbias1 Vbias1 N006 0 sky130_fd_pr__nfet_01v8 w=1.47 l=0.15
xm5 N010 Vbiasn 0 0 sky130_fd_pr__nfet_01v8 w=1.47 l=0.15
xm16 N009 Vbiasn 0 0 sky130_fd_pr__nfet_01v8 w=1.47 l=0.15
xm18 N006 VCM N009 0 sky130_fd_pr__nfet_01v8 w=1.47 l=0.15
xm19 Vbias2 VCM N010 0 sky130_fd_pr__nfet_01v8 w=1.47 l=0.15
xm1 N002 Vbias1 VDD VDD sky130_fd_pr__pfet_01v8 w=1.47 l=0.15
xm4 vomd Vbias2 N001 VDD sky130_fd_pr__pfet_01v8 w=1.47 l=0.15
xm7 vopd Vbias2 N002 VDD sky130_fd_pr__pfet_01v8 w=1.47 l=0.15
xm8 vopd Vbias1 N012 0 sky130_fd_pr__nfet_01v8 w=1.47 l=0.15
xm11 N011 vp N014 0 sky130_fd_pr__nfet_01v8 w=1.47 l=0.15
xm12 N012 vm N014 0 sky130_fd_pr__nfet_01v8 w=1.47 l=0.15
xm14 N014 Vbiasn 0 0 sky130_fd_pr__nfet_01v8 w=1.47 l=0.15
xm15 N014 VCMFB1 0 0 sky130_fd_pr__nfet_01v8 w=1.47 l=0.15
xm17 vomd phi1b vopd VDD sky130_fd_pr__pfet_01v8 w=1.47 l=0.15
Vphi1 phi1 0 Pulse 0 1 0 200p 200p 4n 10n
Vphi2 phi1b 0 Pulse 1 0 0 200p 200p 4n 10n
Vphi3 phi2 0 Pulse 0 1 5n 200p 200p 4n 10n
Vphi4 phi2b 0 Pulse 1 0 5n 200p 200p 4n 10n
xm20 vomd phi1 vopd 0 sky130_fd_pr__nfet_01v8 w=1.47 l=0.15
X_X1 Vbiasn Vbias1 vopd vomd phi1 phi1b phi2 phi2b VCMFB1 VDD 0 Fig_26_50
xm21 vp phi1b VCM VDD sky130_fd_pr__pfet_01v8 w=1.47 l=0.15
xm22 vp phi1 VCM 0 sky130_fd_pr__nfet_01v8 w=1.47 l=0.15
xm23 vm phi1b VCM VDD sky130_fd_pr__pfet_01v8 w=1.47 l=0.15
xm24 vm phi1 VCM 0 sky130_fd_pr__nfet_01v8 w=1.47 l=0.15
C1 N011 vop 5e-14
C2 vom N012 5e-14
xm25 vom vopd VDD VDD sky130_fd_pr__pfet_01v8 w=1.47 l=0.15
xm26 N004 vomd VDD VDD sky130_fd_pr__pfet_01v8 w=1.47 l=0.15
xm27 vom N004 N013 0 sky130_fd_pr__nfet_01v8 w=1.47 l=0.15
xm28 N004 N004 N008 0 sky130_fd_pr__nfet_01v8 w=1.47 l=0.15
xm29 vop vomd VDD VDD sky130_fd_pr__pfet_01v8 w=1.47 l=0.15
xm30 N005 vopd VDD VDD sky130_fd_pr__pfet_01v8 w=1.47 l=0.15
xm31 vop N005 N013 0 sky130_fd_pr__nfet_01v8 w=1.47 l=0.15
xm32 N005 N005 N007 0 sky130_fd_pr__nfet_01v8 w=1.47 l=0.15
xm33 N013 VCMFB2 0 0 sky130_fd_pr__nfet_01v8 w=1.47 l=0.15
xm34 N013 VCMFB2 0 0 sky130_fd_pr__nfet_01v8 w=1.47 l=0.15
xm35 N007 VCM 0 0 sky130_fd_pr__nfet_01v8 w=1.47 l=0.15
xm36 N008 VCM 0 0 sky130_fd_pr__nfet_01v8 w=1.47 l=0.15
xm37 vop phi1b vom VDD sky130_fd_pr__pfet_01v8 w=1.47 l=0.15
xm38 vop phi1 vom 0 sky130_fd_pr__nfet_01v8 w=1.47 l=0.15
X_X2 VCM VCM vop vom phi1 phi1b phi2 phi2b VCMFB2 VDD 0 Fig_26_50
.subckt Fig_26_3 Vbiasn Vbiasp VDD GND
  xmsu2 N002 N002 VDD VDD sky130_fd_pr__pfet_01v8 w=1 l=0.15
  xmsu1 N002 Vbiasn GND 0 sky130_fd_pr__nfet_01v8 w=0.5 l=0.15
  xmsu3 Vbiasp N002 Vbiasn 0 sky130_fd_pr__nfet_01v8 w=1 l=0.15
  xm3 Vbiasn Vbiasp VDD VDD sky130_fd_pr__pfet_01v8 w=1 l=0.15
  xm4 N003 Vbiasp VDD VDD sky130_fd_pr__pfet_01v8 w=1 l=0.15
  xm1 Vbiasn Vbiasn 0 0 sky130_fd_pr__nfet_01v8 w=0.5 l=0.15
  R1 N004 0 4k
  xma4 Vbiasp N001 VDD VDD sky130_fd_pr__pfet_01v8 w=1 l=0.15
  xma3 N001 N001 VDD VDD sky130_fd_pr__pfet_01v8 w=1 l=0.15
  xm5 N001 N003 0 0 sky130_fd_pr__nfet_01v8 w=0.5 l=0.15
  xm7 VDD Vbiasp VDD VDD sky130_fd_pr__pfet_01v8 w=5 l=5
  xm2 Vbiasp Vbiasn 0 0 sky130_fd_pr__nfet_01v8 w=0.5 l=0.15
  xm6 N003 N003 N004 0 sky130_fd_pr__nfet_01v8 w=2 l=0.15
.ends Fig_26_3
.subckt Fig_26_50 ideal_vcmfb ideal_vcma Vop Vom phi1 phi1b phi2 phi2b VCMFB VDD GND
  xm1 ideal_vcma phi1 N001 GND sky130_fd_pr__nfet_01v8 w=0.5 l=0.15
  xm2 N001 phi1b ideal_vcma VDD sky130_fd_pr__pfet_01v8 w=0.5 l=0.15
  xm3 N001 phi2 vop 0 sky130_fd_pr__nfet_01v8 w=0.5 l=0.15
  xm4 vop phi2b N001 VDD sky130_fd_pr__pfet_01v8 w=0.5 l=0.15
  xm5 ideal_vcmfb phi1 N003 0 sky130_fd_pr__nfet_01v8 w=0.5 l=0.15
  xm6 N003 phi1b ideal_vcmfb VDD sky130_fd_pr__pfet_01v8 w=0.5 l=0.15
  xm7 N003 phi2 VCMFB 0 sky130_fd_pr__nfet_01v8 w=0.5 l=0.15
  xm8 VCMFB phi2b N003 VDD sky130_fd_pr__pfet_01v8 w=0.5 l=0.15
  C1 N001 N003 50f
  C2 vop VCMFB 10f
  xm9 ideal_vcma phi1 N002 0 sky130_fd_pr__nfet_01v8 w=0.5 l=0.15
  xm10 N002 phi1b ideal_vcma VDD sky130_fd_pr__pfet_01v8 w=0.5 l=0.15
  xm11 N002 phi2 vom 0 sky130_fd_pr__nfet_01v8 w=0.5 l=0.15
  xm12 vom phi2b N002 VDD sky130_fd_pr__pfet_01v8 w=0.5 l=0.15
  xm13 ideal_vcmfb phi1 N004 0 sky130_fd_pr__nfet_01v8 w=0.5 l=0.15
  xm14 N004 phi1b ideal_vcmfb VDD sky130_fd_pr__pfet_01v8 w=0.5 l=0.15
  xm15 N004 phi2 VCMFB 0 sky130_fd_pr__nfet_01v8 w=0.5 l=0.15
  xm16 VCMFB phi2b N004 VDD sky130_fd_pr__pfet_01v8 w=0.5 l=0.15
  C3 N002 N004 50f
  C4 vom VCMFB 10f
.ends Fig_26_50

.control
op

let vdd_current = abs(i(VDD))
let power_dc = vdd_current * 1.0
print power_dc

* Print all node voltages for diagnosis
print all

quit
.endc

.end
