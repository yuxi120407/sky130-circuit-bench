* Circuit: Chap18_LTspice/Fig18_18
.lib ${SKY130_PDK} tt

xm1 N001 Vinm N003 0 sky130_fd_pr__nfet_01v8 w=1.47 l=0.15
Vinp Vinp 0 500m
VDD VDD 0 1
xm3 N001 N001 VDD VDD sky130_fd_pr__pfet_01v8 w=1.47 l=0.15
xm4 N002 N001 VDD VDD sky130_fd_pr__pfet_01v8 w=1.47 l=0.15
xm2 N002 Vinp N003 0 sky130_fd_pr__nfet_01v8 w=1.47 l=0.15
Vinm Vinm 0 500m
xm6 N003 N001 0 0 sky130_fd_pr__nfet_01v8 w=1.47 l=0.15
xm5 Vout N002 VDD VDD sky130_fd_pr__pfet_01v8 w=1.47 l=0.15
xm7 Vout N002 0 0 sky130_fd_pr__nfet_01v8 w=1.47 l=0.15

.control
op

let vdd_current = abs(i(VDD))
let power_dc = vdd_current * 1.0
print power_dc

* Print all node voltages for diagnosis
print all

quit
.endc

.end
