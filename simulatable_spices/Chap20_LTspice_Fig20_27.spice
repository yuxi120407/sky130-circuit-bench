* Circuit: Chap20_LTspice/Fig20_27
.lib ${SKY130_PDK} tt

VDD VDD 0 5
xmsu2 N001 N001 VDD VDD sky130_fd_pr__pfet_01v8 w=1.47 l=20
xmsu1 N001 Vref 0 0 sky130_fd_pr__nfet_01v8 w=1.47 l=2
xmsu3 N002 N001 Vref 0 sky130_fd_pr__nfet_01v8 w=1.47 l=1
xm3 Vref N002 VDD VDD sky130_fd_pr__pfet_01v8 w=1.47 l=2
xm4 N002 N002 VDD VDD sky130_fd_pr__pfet_01v8 w=1.47 l=2
xm1 Vref Vref 0 0 sky130_fd_pr__nfet_01v8 w=1.47 l=2
xm2 N002 Vref N003 0 sky130_fd_pr__nfet_01v8 w=1.47 l=2
R1 N003 0 5000.0

.control
op

let vdd_current = abs(i(VDD))
let power_dc = vdd_current * 5.0
print power_dc

* Print all node voltages for diagnosis
print all

quit
.endc

.end
