* CIRCUIT: Chap16_LTspice_Fig16_28
* YAML: /home/idies/workspace/Storage/xyu1/persistent/ALIGN-public/simple_circuit_5/OpenManus/autosizer_plus/circuits_yaml_generated/Chap16_LTspice__Fig16_28.yaml
* Variables: ['W_nfet_g0', 'W_nfet_g1']
* Trial values (midpoint): [1.47, 1.47]
* Metrics: ['avg_power', 'vout_swing', 'rise_time', 'fall_time', 'fom']
* Class: mosfet_analog_tran
* FOM: 3.955855140136933e-10
* FIXED: node rename {'vout': 'Outp'}

* Circuit: Chap16_LTspice/Fig16_28
.lib ${SKY130_PDK} tt

xm1 N001 clock 0 0 sky130_fd_pr__nfet_01v8 w=1.47 l=0.15
VDD VDD 0 1
xm11 Outm clock Inm VDD sky130_fd_pr__pfet_01v8 w=1.47 l=0.15
xm2 Outp Outm VDD VDD sky130_fd_pr__pfet_01v8 w=1.47 l=0.15
xm3 Outm Outp VDD VDD sky130_fd_pr__pfet_01v8 w=1.47 l=0.15
xm4 Inp clock Outp VDD sky130_fd_pr__pfet_01v8 w=1.47 l=0.15
xm5 Outm Outp N001 0 sky130_fd_pr__nfet_01v8 w=1.47 l=0.15
xm6 Outp Outm N001 0 sky130_fd_pr__nfet_01v8 w=1.47 l=0.15
Vclock clock 0 PULSE(0 1 0 10p 10p 5n 10n)
xm7 Inm 0 VDD VDD sky130_fd_pr__pfet_01v8 w=1.47 l=0.5
xm8 Inm 0 0 0 sky130_fd_pr__nfet_01v8 w=1.47 l=0.5
xm9 Inp VDD VDD VDD sky130_fd_pr__pfet_01v8 w=1.47 l=0.5
xm10 Inp VDD 0 0 sky130_fd_pr__nfet_01v8 w=1.47 l=0.5

.control
tran 1p 100n

let power = v(VDD) * abs(i(VDD))
let avg_power = mean(power)
print avg_power

meas tran vout_max MAX v(Outp)
meas tran vout_min MIN v(Outp)
let vout_swing = vout_max - vout_min
print vout_swing

meas tran rise_time TRIG v(Outp) VAL='0.1*vout_max' RISE=1 TARG v(Outp) VAL='0.9*vout_max' RISE=1
meas tran fall_time TRIG v(Outp) VAL='0.9*vout_max' FALL=1 TARG v(Outp) VAL='0.1*vout_max' FALL=1
print rise_time fall_time

quit
.endc

.end
