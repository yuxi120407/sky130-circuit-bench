* Circuit: Chap20_LTspice/Fig20_39
.lib ${SKY130_PDK} tt

VDD VDD 0 1
xm2 N004 N001 0 0 sky130_fd_pr__nfet_01v8 w=1.47 l=0.15
Vo N002 0 0
X_U1 Vbiasn Vbiasp VDD 0 Fig_20_22
xmws N003 N003 0 0 sky130_fd_pr__nfet_01v8 w=1.47 l=0.2
xm1 P001 N001 0 0 sky130_fd_pr__nfet_01v8 w=1.47 l=0.15
xm4 N002 N003 N004 0 sky130_fd_pr__nfet_01v8 w=1.47 l=0.15
xm5a N003 Vbiasp VDD VDD sky130_fd_pr__pfet_01v8 w=1.47 l=0.15
xm6b N001 Vbiasp VDD VDD sky130_fd_pr__pfet_01v8 w=1.47 l=0.15
xm3 N001 N003 P001 0 sky130_fd_pr__nfet_01v8 w=1.47 l=0.15
.subckt Fig_20_22 Vbiasn Vbiasp VDD GND
  xmsu2 N002 N002 VDD VDD sky130_fd_pr__pfet_01v8 w=1 l=0.15
  xmsu1 N002 Vbiasn GND 0 sky130_fd_pr__nfet_01v8 w=1 l=0.15
  xmsu3 Vbiasp N002 Vbiasn 0 sky130_fd_pr__nfet_01v8 w=1 l=0.15
  xm3 Vbiasn Vbiasp VDD VDD sky130_fd_pr__pfet_01v8 w=5 l=0.15
  xm4 N003 Vbiasp VDD VDD sky130_fd_pr__pfet_01v8 w=5 l=0.15
  xm1 Vbiasn Vbiasn 0 0 sky130_fd_pr__nfet_01v8 w=1 l=0.15
  R1 N004 0 5.5k
  xma4 Vbiasp N001 VDD VDD sky130_fd_pr__pfet_01v8 w=5 l=0.15
  xma3 N001 N001 VDD VDD sky130_fd_pr__pfet_01v8 w=5 l=0.15
  xm5 N001 N003 0 0 sky130_fd_pr__nfet_01v8 w=1 l=0.15
  xm7 VDD Vbiasp VDD VDD sky130_fd_pr__pfet_01v8 w=5 l=5
  xm8 0 Vbiasn 0 0 sky130_fd_pr__nfet_01v8 w=5 l=5
  xm2 Vbiasp Vbiasn 0 0 sky130_fd_pr__nfet_01v8 w=1 l=0.15
  xm6 N003 N003 N004 0 sky130_fd_pr__nfet_01v8 w=10 l=0.15
.ends Fig_20_22

.control
dc Vo 0 1.0 0.005

let iout = abs(i(Vo))
let iout_deriv = deriv(iout)
let rout = 1.0 / abs(iout_deriv)

meas dc iout_mid FIND iout AT=0.5
meas dc rout_mid FIND rout AT=0.5

let vdd_current = abs(i(VDD))
let power_dc = mean(vdd_current) * 1.0
print iout_mid rout_mid power_dc

quit
.endc

.end
