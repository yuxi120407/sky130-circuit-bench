* Circuit: Chap13_LTspice/Fig13_34
.lib ${SKY130_PDK} tt

xm1 B A 0 0 sky130_fd_pr__nfet_01v8 w=1.47 l=0.15
VDD VDD 0 1
xm2 B A VDD VDD sky130_fd_pr__pfet_01v8 w=1.47 l=0.15
xm5 N001 B 0 0 sky130_fd_pr__nfet_01v8 w=1.47 l=0.15
xm6 N001 B VDD VDD sky130_fd_pr__pfet_01v8 w=1.47 l=0.15
xm7 D VDD A 0 sky130_fd_pr__nfet_01v8 w=1.47 l=0.15
VD D 0 PULSE 0 1 500p 10p 10p 300p
xm3 A 0 D VDD sky130_fd_pr__pfet_01v8 w=1.47 l=0.15
xm4 A 0 N001 0 sky130_fd_pr__nfet_01v8 w=1.47 l=0.15
xm8 N001 VDD A VDD sky130_fd_pr__pfet_01v8 w=1.47 l=0.15
xm9 N001 0 N002 0 sky130_fd_pr__nfet_01v8 w=1.47 l=0.15
xm10 N002 VDD N001 VDD sky130_fd_pr__pfet_01v8 w=1.47 l=0.15

.control
op

let vdd_current = abs(i(VDD))
let power_dc = vdd_current * 1.0
print power_dc

* Print all node voltages for diagnosis
print all

quit
.endc

.end
