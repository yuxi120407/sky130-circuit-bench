* Circuit: Chap20_LTspice/Fig20_18
.lib ${SKY130_PDK} tt

VDD VDD 0 1
xmsu2 N001 N001 VDD VDD sky130_fd_pr__pfet_01v8 w=1 l=0.15
xmsu1 N001 Vbiasn 0 0 sky130_fd_pr__nfet_01v8 w=1 l=0.15
xmsu3 Vbiasp N001 Vbiasn 0 sky130_fd_pr__nfet_01v8 w=1 l=0.15
xm3 Vbiasn Vbiasp VDD VDD sky130_fd_pr__pfet_01v8 w=1.47 l=0.15
xm4 Vbiasp Vbiasp VDD VDD sky130_fd_pr__pfet_01v8 w=1.47 l=0.15
xm1 Vbiasn Vbiasn 0 0 sky130_fd_pr__nfet_01v8 w=1 l=0.15
xm2 Vbiasp Vbiasn N002 0 sky130_fd_pr__nfet_01v8 w=1 l=0.15
R1 N002 0 6500.0

.control
op

let vdd_current = abs(i(VDD))
let power_dc = vdd_current * 1.0
print power_dc

print all

quit
.endc

.end
