* CIRCUIT: bandgap_reference
* YAML: /home/idies/workspace/Storage/xyu1/persistent/ALIGN-public/simple_circuit_5/OpenManus/autosizer_plus/circuits_yaml/bandgap_reference.yaml
* Variables: ['W_mp', 'L_mp', 'W_mn', 'L_mn', 'L_ra', 'L_rb']
* Trial values (midpoint): [25, 3, 20, 1.5, 40, 113]
* Metrics: ['vref', 'power_uw', 'line_regulation_percent', 'psrr_100hz_db', 'fom']
* Class: unknown

* Bandgap Reference
.lib ${SKY130_PDK} tt
.include /home/idies/workspace/Temporary/xyu1/scratch/skywater-pdk-libs-sky130_fd_pr/cells/pnp_05v5/sky130_fd_pr__pnp_05v5_W3p40L3p40.model.spice
.global VDD GND
.temp 27

* Bandgap Reference Circuit
* Current Mirror (PMOS)
XMP1 NET1 NET2 VDD VDD sky130_fd_pr__pfet_01v8_lvt l=3 w=25 m=3
XMP2 NET2 NET2 VDD VDD sky130_fd_pr__pfet_01v8_lvt l=3 w=25 m=3
XMP3 NET3 NET2 VDD VDD sky130_fd_pr__pfet_01v8_lvt l=3 w=25 m=1

* NMOS devices
XMN1 NET1 NET1 QP1 GND sky130_fd_pr__nfet_01v8_lvt l=1.5 w=20 m=2
XMN2 NET2 NET2 RA_TOP GND sky130_fd_pr__nfet_01v8_lvt l=1.5 w=20 m=2

* Startup Circuit
XMP4 NET4 NET2 VDD VDD sky130_fd_pr__pfet_01v8_lvt l=3 w=5 m=1
XMP5 NET5 NET2 NET4 VDD sky130_fd_pr__pfet_01v8_lvt l=3 w=5 m=1
XMP6 NET7 NET6 NET2 VDD sky130_fd_pr__pfet_01v8_lvt l=3 w=5 m=2
XMN3 NET6 NET6 NET8 GND sky130_fd_pr__nfet_01v8_lvt l=7 w=1 m=1
XMN4 NET8 NET8 GND GND sky130_fd_pr__nfet_01v8_lvt l=7 w=1 m=1

* BJTs
XQP1 GND GND QP1 VDD sky130_fd_pr__pnp_05v5_W3p40L3p40 m=1
XQP2 GND GND QP2 VDD sky130_fd_pr__pnp_05v5_W3p40L3p40 m=8
XQP3 GND GND QP3 VDD sky130_fd_pr__pnp_05v5_W3p40L3p40 m=1

* Resistors
XRA RA_TOP QP2 VDD sky130_fd_pr__res_high_po_1p41 w=1.41 l=40
XRB NET3 QP3 VDD sky130_fd_pr__res_high_po_1p41 w=1.41 l=113

* Sources
VDD VDD GND DC 2.0

.control
set noaskquit
op
let vref = v(NET3)
print vref
let vdd_i = abs(i(VDD))
let power_uw = vdd_i * 2.0 * 1e6
print power_uw

* Line regulation: vary VDD from 1.6 to 2.0
alter VDD dc = 1.6
op
let vref_low = v(NET3)
alter VDD dc = 2.0
op
let vref_high = v(NET3)
let line_regulation_percent = abs(vref_high - vref_low) / vref * 100
print line_regulation_percent

alter VDD dc = 2.0
ac dec 10 1 1Meg
let psrr_100hz_db = db(v(NET3))[20]
print psrr_100hz_db

quit
.endc

.end
