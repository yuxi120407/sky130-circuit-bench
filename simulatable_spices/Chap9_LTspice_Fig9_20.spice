* Circuit: Chap9_LTspice/Fig9_20
.lib ${SKY130_PDK} tt

xm2 vd24 N001 vs12 0 sky130_fd_pr__nfet_01v8 w=1 l=0.15
VDD VDD 0 5
Ibias vs12 0 40µ
xm1 vd13 vg1 vs12 0 sky130_fd_pr__nfet_01v8 w=1.47 l=2
xm4 vd24 0 VDD VDD sky130_fd_pr__pfet_01v8 w=1.47 l=2
xm3 vd13 vd13 VDD VDD sky130_fd_pr__pfet_01v8 w=1.47 l=2
VG1 vg1 0 SINE(2.5 1m 10k) AC 1m
VG2 N001 0 2.5

.control
op

let vdd_current = abs(i(VDD))
let power_dc = vdd_current * 5.0
print power_dc

* Print all node voltages for diagnosis
print all

quit
.endc

.end
