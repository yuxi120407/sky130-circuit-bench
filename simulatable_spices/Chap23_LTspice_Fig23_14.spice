* Circuit: Chap23_LTspice/Fig23_14
.lib ${SKY130_PDK} tt

VDD VDD 0 1
xmsu1 N002 Vbiasn 0 0 sky130_fd_pr__nfet_01v8 w=1.47 l=0.15
xmsu3 Vbiasp N002 Vbiasn 0 sky130_fd_pr__nfet_01v8 w=1.47 l=0.15
xmsu2 N002 N002 VDD VDD sky130_fd_pr__pfet_01v8 w=1.47 l=1
xm3t Vbiasn Vbiasp VDD VDD sky130_fd_pr__pfet_01v8 w=1.47 l=0.15
xm4t VREF Vbiasp VDD VDD sky130_fd_pr__pfet_01v8 w=1.47 l=0.15
xm2 VREF VREF N003 0 sky130_fd_pr__nfet_01v8 w=1.47 l=0.15
xm1 Vbiasn Vbiasn 0 0 sky130_fd_pr__nfet_01v8 w=1.47 l=0.15
R1 N003 0 5500.0
xma4 Vbiasp N001 VDD VDD sky130_fd_pr__pfet_01v8 w=1.47 l=0.15
xma3 N001 N001 VDD VDD sky130_fd_pr__pfet_01v8 w=1.47 l=0.15
xma1 N001 VREF 0 0 sky130_fd_pr__nfet_01v8 w=1 l=0.15
xma2 Vbiasp Vbiasn 0 0 sky130_fd_pr__nfet_01v8 w=1 l=0.15
xm3 VDD Vbiasp VDD VDD sky130_fd_pr__pfet_01v8 w=1.47 l=5

.control
op

let vdd_current = abs(i(VDD))
let power_dc = vdd_current * 1.0
print power_dc

* Print all node voltages for diagnosis
print all

quit
.endc

.end
