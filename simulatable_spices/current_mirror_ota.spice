* CIRCUIT: current_mirror_ota
* YAML: /home/idies/workspace/Storage/xyu1/persistent/ALIGN-public/simple_circuit_5/OpenManus/autosizer_plus/circuits_yaml/current_mirror_ota.yaml
* Variables: ['W_tail_base', 'W_diff_base', 'W_mirror_base', 'W_casc_base']
* Trial values (midpoint): [1.68, 1.68, 1.68, 1.68]
* Metrics: ['dc_gain_db', 'ugbw', 'power_dc', 'fom']
* Class: unknown

* OTA testbench
  .lib ${SKY130_PDK} tt

  .subckt CURRENT_MIRROR_OTA VSS VDD VOUT VINN VINP ID
XM5 ID ID VSS VSS sky130_fd_pr__nfet_01v8 w=6.72 l=0.15
XM4 SOURCE ID VSS VSS sky130_fd_pr__nfet_01v8 w=6.72 l=0.15
XM3 NET7 VINN SOURCE VSS sky130_fd_pr__nfet_01v8 w=13.44 l=0.15
XM0 NET8 VINP SOURCE VSS sky130_fd_pr__nfet_01v8 w=13.44 l=0.15
XM2 NET7 NET7 VDD VDD sky130_fd_pr__pfet_01v8 w=10.08 l=0.15
XM1 NET8 NET8 VDD VDD sky130_fd_pr__pfet_01v8 w=10.08 l=0.15
XM6 VOUT NET7 VDD VDD sky130_fd_pr__pfet_01v8 w=20.16 l=0.15
XM7 NET9 NET8 VDD VDD sky130_fd_pr__pfet_01v8 w=20.16 l=0.15
XM8 NET9 NET9 SOURCE VSS sky130_fd_pr__nfet_01v8 w=26.88 l=0.15
XM9 VOUT NET9 SOURCE VSS sky130_fd_pr__nfet_01v8 w=26.88 l=0.15
.ends CURRENT_MIRROR_OTA

  VDD VDD 0 DC 1.8
  VSS VSS 0 DC 0
  IBIAS VDD ID DC 20e-6
  VINP VINP 0 DC 0.9 AC 0.5
  VINN VINN 0 DC 0.9 AC -0.5
  XOTA VSS VDD VOUT VINN VINP ID CURRENT_MIRROR_OTA
  CLOAD VOUT 0 1e-12

  .op

  .control
  op
  let vdd_current = abs(i(VDD))
  let power_dc = vdd_current * 1.8
  print power_dc

  ac dec 100 1 10g
  let vout_ac = v(VOUT)
  let gain_db = db(vout_ac)
  let dc_gain_db = gain_db[0]
  print dc_gain_db

  if dc_gain_db > 0
      meas ac ugbw WHEN gain_db=0 CROSS=1
  end

  quit
  .endc

  .end
