* Circuit: Chap20_LTspice/Fig20_10
.lib ${SKY130_PDK} tt

xm2 0 N001 VDD VDD sky130_fd_pr__pfet_01v8 w=1.47 l=0.15
xm1 N001 N001 VDD VDD sky130_fd_pr__pfet_01v8 w=1.47 l=0.15
VDD VDD 0 1
R1 N001 0 65000.0

.control
op

let vdd_current = abs(i(VDD))
let power_dc = vdd_current * 1.0
print power_dc

print all

quit
.endc

.end
