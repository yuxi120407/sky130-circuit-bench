* CIRCUIT: buffer
* YAML: /home/idies/workspace/Storage/xyu1/persistent/ALIGN-public/simple_circuit_5/OpenManus/autosizer_plus/circuits_yaml/buffer.yaml
* Variables: ['W_pmos1_base', 'W_nmos1_base', 'W_pmos2_base', 'W_nmos2_base']
* Trial values (midpoint): [1.68, 1.68, 1.68, 1.68]
* Metrics: ['dc_gain_db', 'average_delay', 'dynamic_power', 'fom']
* Class: unknown

* Circuit Analysis
.lib ${SKY130_PDK} tt
.option scale=1e-6

.subckt BUFFER IN OUT VSS VDD
* First stage inverter
XM0 OUT1 IN VSS VSS sky130_fd_pr__nfet_01v8 w=16.8 l=0.15
XM2 OUT1 IN VDD VDD sky130_fd_pr__pfet_01v8 w=16.8 l=0.15
* Second stage inverter
XM1 OUT OUT1 VSS VSS sky130_fd_pr__nfet_01v8 w=16.8 l=0.15
XM3 OUT OUT1 VDD VDD sky130_fd_pr__pfet_01v8 w=16.8 l=0.15
.ends BUFFER

* Test circuit
Vdd VDD 0 DC 1.8
Vss VSS 0 DC 0
Vin IN 0 DC 0 PULSE(0 1.8 200p 100p 100p 2n 4n)
Xcircuit IN OUT VSS VDD BUFFER
Cout OUT 0 10e-15

* DC Sweep for Gain
.dc Vin 0 1.8 0.01

.control
run

let vout_deriv = deriv(v(OUT))
let gain_linear = abs(vout_deriv)
let gain_db = db(gain_linear)
meas dc dc_gain_db MAX gain_db

print dc_gain_db
.endc

* Transient for Power and Delay
.control
destroy all
reset
tran 1p 8n

* Power calculation
let power = v(VDD) * (-i(Vdd))
let avg_power = mean(power)
meas tran static_i AVG i(Vdd) from=50p to=150p
let static_power = abs(static_i) * 1.8
let dynamic_power = abs(avg_power - static_power)

* Delay measurements - find 50% crossings
meas tran t_in_r WHEN v(IN)=0.9 CROSS=1
meas tran t_out_r WHEN v(OUT)=0.9 CROSS=1
meas tran t_in_f WHEN v(IN)=0.9 CROSS=2
meas tran t_out_f WHEN v(OUT)=0.9 CROSS=2

let tplh = t_out_r - t_in_r
let tphl = t_out_f - t_in_f
let average_delay = (tplh + tphl)/2

print dynamic_power average_delay
quit
.endc

.end
