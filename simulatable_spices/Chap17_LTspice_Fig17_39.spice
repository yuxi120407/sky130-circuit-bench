* CIRCUIT: Chap17_LTspice_Fig17_39
* YAML: /home/idies/workspace/Storage/xyu1/persistent/ALIGN-public/simple_circuit_5/OpenManus/autosizer_plus/circuits_yaml_generated/Chap17_LTspice__Fig17_39.yaml
* Variables: ['W_nfet_g0', 'W_nfet_g1', 'W_nfet_g2', 'W_nfet_g3', 'W_nfet_g4', 'W_nfet_g5']
* Trial values (midpoint): [1.47, 1.47, 1.47, 1.47, 1.47, 1.47]
* Metrics: ['avg_power', 'vout_swing', 'rise_time', 'fall_time', 'fom']
* Class: mosfet_analog_tran
* FOM: 7.0983714324524e-10
* FIXED: node rename {'vout': 'out'}

* Circuit: Chap17_LTspice/Fig17_39
.lib ${SKY130_PDK} tt

VDD VDD 0 1
xm3 VDD N006 VDD VDD sky130_fd_pr__pfet_01v8 w=1.47 l=0.5
Vphi1 Phi1 0 PULSE(0 1 1n 10p 10p 4n 10n)
Vphi2 phi2 0 PULSE(0 1 6n 10p 10p 4n 10n)
xm5 N007 phi2 0 0 sky130_fd_pr__nfet_01v8 w=1.47 l=0.15
xm7 vbuck vbucki VDD VDD sky130_fd_pr__pfet_01v8 w=1.47 l=0.5
Vr Vr 0 650m
Vi N001 0 640m
xm1 N006 phi2 0 0 sky130_fd_pr__nfet_01v8 w=1.47 l=0.15
xm2 N005 phi1 N007 0 sky130_fd_pr__nfet_01v8 w=1.47 l=0.15
xm4 N004 phi1 N006 0 sky130_fd_pr__nfet_01v8 w=1.47 l=0.15
xm6 N003 VDD N005 0 sky130_fd_pr__nfet_01v8 w=1.47 l=0.15
xm8 N002 Q N004 0 sky130_fd_pr__nfet_01v8 w=1.47 l=0.15
xm9 vbuck Vi N003 0 sky130_fd_pr__nfet_01v8 w=1.47 l=0.15
xm10 vbucki Vr N002 0 sky130_fd_pr__nfet_01v8 w=1.47 l=0.15
xm11 VDD N007 VDD VDD sky130_fd_pr__pfet_01v8 w=1.47 l=0.5
xm12 vbucki vbucki VDD VDD sky130_fd_pr__pfet_01v8 w=1.47 l=0.5
xm13 0 vbuck 0 0 sky130_fd_pr__nfet_01v8 w=1.47 l=0.5
xm14 0 vbucki 0 0 sky130_fd_pr__nfet_01v8 w=1.47 l=0.5
xm15 n1 vbuck VDD VDD sky130_fd_pr__pfet_01v8 w=1.47 l=0.15
xm16 n2 vbucki VDD VDD sky130_fd_pr__pfet_01v8 w=1.47 l=0.15
xm17 n3 Out n1 VDD sky130_fd_pr__pfet_01v8 w=1.47 l=0.15
xm18 n4 Outi n2 VDD sky130_fd_pr__pfet_01v8 w=1.47 l=0.15
xm19 Outi phi2 n3 VDD sky130_fd_pr__pfet_01v8 w=1.47 l=0.15
xm20 Out phi2 n4 VDD sky130_fd_pr__pfet_01v8 w=1.47 l=0.15
xm21 Out Outi 0 0 sky130_fd_pr__nfet_01v8 w=1.47 l=0.15
xm22 Outi Out 0 0 sky130_fd_pr__nfet_01v8 w=1.47 l=0.15
xm23 Outi phi2 0 0 sky130_fd_pr__nfet_01v8 w=1.47 l=0.15
xm24 Out phi2 0 0 sky130_fd_pr__nfet_01v8 w=1.47 l=0.15
X_U1 Out Qi Q VDD 0 NOR_2
X_U2 Q Outi Qi VDD 0 NOR_2
Vos N001 Vi 20m
.subckt NOR_2 A B Out VDD GND
  xm3 out B N001 VDD sky130_fd_pr__pfet_01v8 w=1 l=0.15
  xm8 N001 A VDD VDD sky130_fd_pr__pfet_01v8 w=1 l=0.15
  xm11 out B GND 0 sky130_fd_pr__nfet_01v8 w=0.5 l=0.15
  xm12 out A 0 0 sky130_fd_pr__nfet_01v8 w=0.5 l=0.15
.ends NOR_2

.control
tran 1p 100n

let power = v(VDD) * abs(i(VDD))
let avg_power = mean(power)
print avg_power

meas tran vout_max MAX v(out)
meas tran vout_min MIN v(out)
let vout_swing = vout_max - vout_min
print vout_swing

meas tran rise_time TRIG v(out) VAL='0.1*vout_max' RISE=1 TARG v(out) VAL='0.9*vout_max' RISE=1
meas tran fall_time TRIG v(out) VAL='0.9*vout_max' FALL=1 TARG v(out) VAL='0.1*vout_max' FALL=1
print rise_time fall_time

quit
.endc

.end
