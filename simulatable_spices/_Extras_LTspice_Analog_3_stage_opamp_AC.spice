* CIRCUIT: _Extras_LTspice/Analog/3_stage_opamp_AC
* FOM: 0.06727476488364337

* Circuit: _Extras_LTspice/Analog/3_stage_opamp_AC
.lib ${SKY130_PDK} tt

VDD VDD 0 1
xm2 fbr Vp N002 0 sky130_fd_pr__nfet_01v8 w=1.47 l=0.15
xm1 fbl Vm N002 0 sky130_fd_pr__nfet_01v8 w=1.47 l=0.15
xm4 out12 out11 VDD VDD sky130_fd_pr__pfet_01v8 w=1.47 l=0.15
xm3 out11 out11 VDD VDD sky130_fd_pr__pfet_01v8 w=1.47 l=0.15
xm6t N002 Vbiasn 0 0 sky130_fd_pr__nfet_01v8 w=1.47 l=0.15
VCM Vp 0 500m AC 1
X_U1 Vbiasn Vbiasp VDD 0 Fig_26_3
xm5 N002 Vbiasn 0 0 sky130_fd_pr__nfet_01v8 w=1.47 l=0.15
xm6 N001 Vbiasp VDD VDD sky130_fd_pr__pfet_01v8 w=1.47 l=0.15
xm7 N001 Vbiasp VDD VDD sky130_fd_pr__pfet_01v8 w=1.47 l=0.15
xm8 out12 Vp fbr 0 sky130_fd_pr__nfet_01v8 w=1.47 l=0.15
xm9 out11 Vm fbl 0 sky130_fd_pr__nfet_01v8 w=1.47 l=0.15
xm10 Out22 N003 0 0 sky130_fd_pr__nfet_01v8 w=1.47 l=0.15
xm11 N003 N003 0 0 sky130_fd_pr__nfet_01v8 w=1.47 l=0.15
xm12 N003 Out12 N001 VDD sky130_fd_pr__pfet_01v8 w=1.47 l=0.15
xm13 Out22 Out11 N001 VDD sky130_fd_pr__pfet_01v8 w=1.47 l=0.15
xm14 out Out22 0 0 sky130_fd_pr__nfet_01v8 w=1.47 l=0.15
xm15 out Out12 VDD VDD sky130_fd_pr__pfet_01v8 w=1.47 l=0.15
C1 out 0 1e-11
C2 out fbr 2.4e-13
C3 Out22 fbl 2.4e-13
C4 Vm 0 1e-06
R1 out Vm 10000000.0
.subckt Fig_26_3 Vbiasn Vbiasp VDD GND
  xmsu2 N002 N002 VDD VDD sky130_fd_pr__pfet_01v8 w=1 l=0.15
  xmsu1 N002 Vbiasn GND 0 sky130_fd_pr__nfet_01v8 w=0.5 l=0.15
  xmsu3 Vbiasp N002 Vbiasn 0 sky130_fd_pr__nfet_01v8 w=1 l=0.15
  xm3 Vbiasn Vbiasp VDD VDD sky130_fd_pr__pfet_01v8 w=1 l=0.15
  xm4 N003 Vbiasp VDD VDD sky130_fd_pr__pfet_01v8 w=1 l=0.15
  xm1 Vbiasn Vbiasn 0 0 sky130_fd_pr__nfet_01v8 w=0.5 l=0.15
  R1 N004 0 4k
  xma4 Vbiasp N001 VDD VDD sky130_fd_pr__pfet_01v8 w=1 l=0.15
  xma3 N001 N001 VDD VDD sky130_fd_pr__pfet_01v8 w=1 l=0.15
  xm5 N001 N003 0 0 sky130_fd_pr__nfet_01v8 w=0.5 l=0.15
  xm7 VDD Vbiasp VDD VDD sky130_fd_pr__pfet_01v8 w=5 l=5
  xm2 Vbiasp Vbiasn 0 0 sky130_fd_pr__nfet_01v8 w=0.5 l=0.15
  xm6 N003 N003 N004 0 sky130_fd_pr__nfet_01v8 w=2 l=0.15
.ends Fig_26_3

.control
op
let vdd_current = abs(i(VDD))
let power_dc = vdd_current * v(VDD)
print power_dc

ac dec 100 1 10g
let vout_mag = vm(out)
let gain_db = db(vout_mag)
let dc_gain_db = gain_db[0]
print dc_gain_db

if dc_gain_db > 0
    meas ac ugbw WHEN gain_db=0 CROSS=1
end

let phase = vp(out)
let dc_phase = phase[0]

quit
.endc

.end
