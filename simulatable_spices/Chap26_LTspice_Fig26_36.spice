* CIRCUIT: Chap26_LTspice_Fig26_36
* YAML: /home/idies/workspace/Storage/xyu1/persistent/ALIGN-public/simple_circuit_5/OpenManus/autosizer_plus/circuits_yaml_generated/Chap26_LTspice__Fig26_36.yaml
* Variables: ['W_nfet_g0', 'W_nfet_g1', 'W_nfet_g2', 'W_nfet_g3', 'R1', 'R2', 'C3', 'C4', 'C5', 'C6', 'C1', 'C2', 'C7', 'C8', 'C9', 'C10']
* Trial values (midpoint): [1.47, 1.47, 1.47, 1.47, 20000.0, 20000.0, 2.5e-13, 2.5e-13, 2.5e-13, 2.5e-13, 5e-14, 5e-14, 1e-14, 1e-14, 2.5e-13, 2.5e-13]
* Metrics: ['avg_power', 'vout_swing', 'rise_time', 'fall_time', 'fom']
* Class: mosfet_analog_tran
* FOM: 5.903021505237087e-12
* FIXED: node rename {'vout': 'voutm'}

* Circuit: Chap26_LTspice/Fig26_36
.lib ${SKY130_PDK} tt

VDD VDD 0 1
VCM VCM 0 500m
X_U1 Vbiasn Vbiasp VDD 0 Fig_26_3
Vinp Vinp 0 SIN 500m 100m 5MEG
Vinm Vinm 0 SIN 500m -100m 5MEG
xm30 vinp phi2 N002 0 sky130_fd_pr__nfet_01v8 w=1.47 l=0.15
C3 N002 Vm 2.5e-13
xm32 vinm phi2 N009 0 sky130_fd_pr__nfet_01v8 w=1.47 l=0.15
C4 N009 Vp 2.5e-13
xm34 N002 phi3 Vop 0 sky130_fd_pr__nfet_01v8 w=1.47 l=0.15
xm36 N009 phi3 Vom 0 sky130_fd_pr__nfet_01v8 w=1.47 l=0.15
xm38 Vm phi1 Vop 0 sky130_fd_pr__nfet_01v8 w=1.47 l=0.15
xm40 Vp phi1 Vom 0 sky130_fd_pr__nfet_01v8 w=1.47 l=0.15
xm42 Vop phi3 Voutp 0 sky130_fd_pr__nfet_01v8 w=1.47 l=0.15
xm44 Vom phi3 voutm 0 sky130_fd_pr__nfet_01v8 w=1.47 l=0.15
C5 Voutp 0 2.5e-13
C6 voutm 0 2.5e-13
Vphi1 phi1 0 PULSE(1 0 5n 0 0 5n 10n)
Vphi2 phi2 0 PULSE(1 0 5.2n 0 0 5n 10n)
Vphi3 phi3 0 PULSE(0 1 5.4n 0 0 4n 10n)
xm1 N001 N001 N006 0 sky130_fd_pr__nfet_01v8 w=1.47 l=0.15
xm2 N001 N001 N006 0 sky130_fd_pr__nfet_01v8 w=1.47 l=0.15
xm3 N001 Vbiasn N003 VDD sky130_fd_pr__pfet_01v8 w=1.47 l=0.15
xm4 vodm Vbiasn N004 VDD sky130_fd_pr__pfet_01v8 w=1.47 l=0.15
xm5 N001 Vbiasn N003 VDD sky130_fd_pr__pfet_01v8 w=1.47 l=0.15
xm6 vodp Vbiasn N005 VDD sky130_fd_pr__pfet_01v8 w=1.47 l=0.15
xm7 N003 N001 VDD VDD sky130_fd_pr__pfet_01v8 w=1.47 l=0.15
xm8 N004 N001 VDD VDD sky130_fd_pr__pfet_01v8 w=1.47 l=0.15
xm9 N003 N001 VDD VDD sky130_fd_pr__pfet_01v8 w=1.47 l=0.15
xm10 N005 N001 VDD VDD sky130_fd_pr__pfet_01v8 w=1.47 l=0.15
xm11 vodp N001 ncr 0 sky130_fd_pr__nfet_01v8 w=1.47 l=0.15
xm12 vodm N001 ncl 0 sky130_fd_pr__nfet_01v8 w=1.47 l=0.15
xm13 N008 Vbiasn 0 0 sky130_fd_pr__nfet_01v8 w=1.47 l=0.15
xm14 N008 VCMFB 0 0 sky130_fd_pr__nfet_01v8 w=1.47 l=0.15
xm15 N007 Vbiasn 0 0 sky130_fd_pr__nfet_01v8 w=1.47 l=0.15
xm16 N007 Vbiasn 0 0 sky130_fd_pr__nfet_01v8 w=1.47 l=0.15
xm17 ncr Vm N007 0 sky130_fd_pr__nfet_01v8 w=1.47 l=0.15
xm18 ncl Vp N007 0 sky130_fd_pr__nfet_01v8 w=1.47 l=0.15
xm19 N006 Vp N008 0 sky130_fd_pr__nfet_01v8 w=1.47 l=0.15
xm20 N006 Vm N008 0 sky130_fd_pr__nfet_01v8 w=1.47 l=0.15
xm21 vom vodp VDD VDD sky130_fd_pr__pfet_01v8 w=1.47 l=0.15
xm22 N013 vodm VDD VDD sky130_fd_pr__pfet_01v8 w=1.47 l=0.15
xm23 N015 N013 0 0 sky130_fd_pr__nfet_01v8 w=1.47 l=0.15
xm24 N013 N013 0 0 sky130_fd_pr__nfet_01v8 w=1.47 l=0.15
C1 vom ncr 5e-14
xm25 vop vodm VDD VDD sky130_fd_pr__pfet_01v8 w=1.47 l=0.15
xm26 N012 vodp VDD VDD sky130_fd_pr__pfet_01v8 w=1.47 l=0.15
xm27 N014 N012 0 0 sky130_fd_pr__nfet_01v8 w=1.47 l=0.15
xm28 N012 N012 0 0 sky130_fd_pr__nfet_01v8 w=1.47 l=0.15
C2 vop ncl 5e-14
R1 vop vcma 20000.0
R2 vcma vom 20000.0
C7 vop vcma 1e-14
C8 vcma vom 1e-14
xm29 N010 Vbiasp VDD VDD sky130_fd_pr__pfet_01v8 w=1.47 l=0.15
xm31 VCMFB N011 0 0 sky130_fd_pr__nfet_01v8 w=1.47 l=0.15
xm33 N011 N011 0 0 sky130_fd_pr__nfet_01v8 w=1.47 l=0.15
xm35 N011 vcma N010 VDD sky130_fd_pr__pfet_01v8 w=1.47 l=0.15
xm37 VCMFB VCM N010 VDD sky130_fd_pr__pfet_01v8 w=1.47 l=0.15
xm39 vop VDD N014 0 sky130_fd_pr__nfet_01v8 w=1.47 l=0.15
xm41 vom VDD N015 0 sky130_fd_pr__nfet_01v8 w=1.47 l=0.15
C9 vop 0 2.5e-13
C10 vom 0 2.5e-13
.subckt Fig_26_3 Vbiasn Vbiasp VDD GND
  xmsu2 N002 N002 VDD VDD sky130_fd_pr__pfet_01v8 w=1 l=0.15
  xmsu1 N002 Vbiasn GND 0 sky130_fd_pr__nfet_01v8 w=0.5 l=0.15
  xmsu3 Vbiasp N002 Vbiasn 0 sky130_fd_pr__nfet_01v8 w=1 l=0.15
  xm3 Vbiasn Vbiasp VDD VDD sky130_fd_pr__pfet_01v8 w=1 l=0.15
  xm4 N003 Vbiasp VDD VDD sky130_fd_pr__pfet_01v8 w=1 l=0.15
  xm1 Vbiasn Vbiasn 0 0 sky130_fd_pr__nfet_01v8 w=0.5 l=0.15
  R1 N004 0 4k
  xma4 Vbiasp N001 VDD VDD sky130_fd_pr__pfet_01v8 w=1 l=0.15
  xma3 N001 N001 VDD VDD sky130_fd_pr__pfet_01v8 w=1 l=0.15
  xm5 N001 N003 0 0 sky130_fd_pr__nfet_01v8 w=0.5 l=0.15
  xm7 VDD Vbiasp VDD VDD sky130_fd_pr__pfet_01v8 w=5 l=5
  xm2 Vbiasp Vbiasn 0 0 sky130_fd_pr__nfet_01v8 w=0.5 l=0.15
  xm6 N003 N003 N004 0 sky130_fd_pr__nfet_01v8 w=2 l=0.15
.ends Fig_26_3

.control
tran 1p 100n

let power = v(VDD) * abs(i(VDD))
let avg_power = mean(power)
print avg_power

meas tran vout_max MAX v(voutm)
meas tran vout_min MIN v(voutm)
let vout_swing = vout_max - vout_min
print vout_swing

meas tran rise_time TRIG v(voutm) VAL='0.1*vout_max' RISE=1 TARG v(voutm) VAL='0.9*vout_max' RISE=1
meas tran fall_time TRIG v(voutm) VAL='0.9*vout_max' FALL=1 TARG v(voutm) VAL='0.1*vout_max' FALL=1
print rise_time fall_time

quit
.endc

.end
