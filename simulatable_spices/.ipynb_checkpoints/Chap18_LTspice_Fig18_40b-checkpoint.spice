* CIRCUIT: Chap18_LTspice_Fig18_40b
* YAML: /home/idies/workspace/Storage/xyu1/persistent/ALIGN-public/simple_circuit_5/OpenManus/autosizer_plus/circuits_yaml_generated/Chap18_LTspice__Fig18_40b.yaml
* Variables: ['W_nfet_g0', 'W_nfet_g1', 'Cload']
* Trial values (midpoint): [1.47, 1.47, 1e-13]
* Metrics: ['avg_power', 'vout_swing', 'rise_time', 'fall_time', 'fom']
* Class: mosfet_analog_tran
* FOM: 2.0275899987444007e-12
* FIXED: node rename {'vout': 'out'}

* Auto-generated testbench for Chap18_LTspice/Fig18_40b
.lib /home/idies/workspace/Temporary/xyu1/scratch/skywater-pdk-libs-sky130_fd_pr/combined_models/sky130.lib.spice tt

xm1 N003 R 0 0 sky130_fd_pr__nfet_01v8 w=1.47 l=0.15
VS S 0 PULSE(0 1 0 10p 10p 5ns 10ns)
VDD VDD 0 1
xmc1 S A S 0 sky130_fd_pr__nfet_01v8 w=1.47 l=0.5
xm2 VDD S N003 0 sky130_fd_pr__nfet_01v8 w=1.47 l=0.15
VR R 0 PULSE(0 1 5n 10p 10p 5ns 10ns)
xm3 N004 N003 0 0 sky130_fd_pr__nfet_01v8 w=1.47 l=0.15
xm4 VDD R N004 0 sky130_fd_pr__nfet_01v8 w=1.47 l=0.15
xm5 VDD R A 0 sky130_fd_pr__nfet_01v8 w=1.47 l=0.15
xm6 B A S 0 sky130_fd_pr__nfet_01v8 w=1.47 l=0.15
xm7 A S N004 0 sky130_fd_pr__nfet_01v8 w=1.47 l=0.15
xm8 N002 R 0 0 sky130_fd_pr__nfet_01v8 w=1.47 l=0.15
xm9 B VDD N002 0 sky130_fd_pr__nfet_01v8 w=1.47 l=0.15
xm10 N001 N004 0 0 sky130_fd_pr__nfet_01v8 w=1.47 l=0.15
xmc2 N001 B N001 0 sky130_fd_pr__nfet_01v8 w=1.47 l=0.5
xm12 VDD B N001 0 sky130_fd_pr__nfet_01v8 w=1.47 l=0.15
xm13 VDD B out 0 sky130_fd_pr__nfet_01v8 w=1.47 l=0.15
xm11 out N005 0 0 sky130_fd_pr__nfet_01v8 w=1.47 l=0.15
Cload out 0 1e-13
xm14 N005 S 0 0 sky130_fd_pr__nfet_01v8 w=1.47 l=0.15
xm15 VDD R N005 0 sky130_fd_pr__nfet_01v8 w=1.47 l=0.15

.control
tran 1p 100n

let power = v(VDD) * abs(i(VDD))
let avg_power = mean(power)
print avg_power

meas tran vout_max MAX v(out)
meas tran vout_min MIN v(out)
let vout_swing = vout_max - vout_min
print vout_swing

meas tran rise_time TRIG v(out) VAL='0.1*vout_max' RISE=1 TARG v(out) VAL='0.9*vout_max' RISE=1
meas tran fall_time TRIG v(out) VAL='0.9*vout_max' FALL=1 TARG v(out) VAL='0.1*vout_max' FALL=1
print rise_time fall_time

quit
.endc

.end
