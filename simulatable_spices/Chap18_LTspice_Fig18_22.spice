* CIRCUIT: Chap18_LTspice/Fig18_22
* YAML: /home/idies/workspace/Storage/xyu1/persistent/ALIGN-public/simple_circuit_5/OpenManus/autosizer_plus/circuits_yaml_generated/Chap18_LTspice__Fig18_22.yaml
* Variables: ['W_nfet_g0', 'W_nfet_g1', 'Cload']
* Trial values (midpoint): [1.47, 1.47, 5e-14]
* Metrics: ['avg_power', 'vout_swing', 'rise_time', 'fall_time', 'fom']
* Class: mosfet_analog_tran

* Circuit: Chap18_LTspice/Fig18_22
.lib ${SKY130_PDK} tt

xm1 N003 N003 0 0 sky130_fd_pr__nfet_01v8 w=1.47 l=0.15
Vinp Vinp 0 PULSE(100mV 300mV 5n 5n 5n 5n 20n)
VDD VDD 0 1
xm3 N003 Vinm N001 VDD sky130_fd_pr__pfet_01v8 w=1.47 l=0.15
xm4 N002 Vinp N001 VDD sky130_fd_pr__pfet_01v8 w=1.47 l=0.15
xm2 N002 N003 0 0 sky130_fd_pr__nfet_01v8 w=1.47 l=0.15
Vinm Vinm 0 200m
xm5 Vout N002 VDD VDD sky130_fd_pr__pfet_01v8 w=1.47 l=0.15
xm7 Vout N002 0 0 sky130_fd_pr__nfet_01v8 w=1.47 l=0.15
Cload Vout 0 5e-14
xm6 N001 N003 VDD VDD sky130_fd_pr__pfet_01v8 w=1.47 l=0.15

.control
tran 1p 100n

let power = v(VDD) * abs(i(VDD))
let avg_power = mean(power)
print avg_power

meas tran vout_max MAX v(vout)
meas tran vout_min MIN v(vout)
let vout_swing = vout_max - vout_min
print vout_swing

meas tran rise_time TRIG v(vout) VAL='0.1*vout_max' RISE=1 TARG v(vout) VAL='0.9*vout_max' RISE=1
meas tran fall_time TRIG v(vout) VAL='0.9*vout_max' FALL=1 TARG v(vout) VAL='0.1*vout_max' FALL=1
print rise_time fall_time

quit
.endc

.end
