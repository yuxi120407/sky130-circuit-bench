* Circuit: Chap27_LTspice/Fig27_27
.lib ${SKY130_PDK} tt

E1 vom N002 vp vm 1e4
E2 N002 vop vp vm 1e4
VCM N002 0 1.5V
R1 vm vom 20000.0
R2 vop vp 20000.0
xm1 N001 N005 vm 0 sky130_fd_pr__nfet_01v8 w=1.47 l=2
xm2 N003 N004 vm 0 sky130_fd_pr__nfet_01v8 w=1.47 l=2
xm3 N001 N004 vp 0 sky130_fd_pr__nfet_01v8 w=1.47 l=2
xm4 N003 N005 vp 0 sky130_fd_pr__nfet_01v8 w=1.47 l=2
Vx N001 N003 0
Vxdc N006 0 1.5
Vydc N007 0 3.5
Vy N005 N004 0
R3 N001 N006 20000.0
R4 N003 N006 20000.0
R5 N005 N007 20000.0
R6 N004 N007 20000.0

.control
op

let vdd_current = abs(i(VDD))
let power_dc = vdd_current * 1.0
print power_dc

* Print all node voltages for diagnosis
print all

quit
.endc

.end
