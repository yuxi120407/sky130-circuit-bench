* CIRCUIT: Chap18_LTspice_Fig18_29b
* YAML: /home/idies/workspace/Storage/xyu1/persistent/ALIGN-public/simple_circuit_5/OpenManus/autosizer_plus/circuits_yaml_generated/Chap18_LTspice__Fig18_29b.yaml
* Variables: ['W_M1', 'W_M2', 'R1', 'R2', 'R3', 'C1', 'C2', 'C3', 'C4']
* Trial values (midpoint): [1.47, 1.47, 100000.0, 100000.0, 1000.0, 1e-12, 1e-12, 1e-12, 1e-11]
* Metrics: ['avg_power', 'vout_swing', 'rise_time', 'fall_time', 'fom']
* Class: mosfet_digital_or_small
* FOM: 1.2334382482159043e-11
* FIXED: node rename {'vout': 'out'}

* Circuit: Chap18_LTspice/Fig18_29b
.lib ${SKY130_PDK} tt

Vin Vin 0 PULSE(0 1 0 10p 10p 12n 20n)
VDD VDD 0 1
X_U1 Max In N001 VDD 0 Fig_18_23
X_U2 Min In N002 VDD 0 Fig_18_23
X_U3 In Avg Out VDD 0 Fig_18_23
xm1 Max N001 VDD VDD sky130_fd_pr__pfet_01v8 w=1.47 l=0.15
xm2 Min N002 0 0 sky130_fd_pr__nfet_01v8 w=1.47 l=0.15
C1 Max 0 1e-12
C2 0 Min 1e-12
C3 Avg 0 1e-12
R1 Max Avg 100000.0
R2 Avg Min 100000.0
R3 Vin In 1000.0
C4 In 0 1e-11
.subckt Fig_18_23 Vinp Vinm Out VDD GND
  xm1 N004 Vinm N005 0 sky130_fd_pr__nfet_01v8 w=0.5 l=0.15
  xm3 N004 N004 VDD VDD sky130_fd_pr__pfet_01v8 w=1 l=0.15
  xm4 N002 N004 VDD VDD sky130_fd_pr__pfet_01v8 w=1 l=0.15
  xm2 N002 Vinp N005 0 sky130_fd_pr__nfet_01v8 w=0.5 l=0.15
  xm6 N005 N004 GND 0 sky130_fd_pr__nfet_01v8 w=0.5 l=0.15
  xm5 Out N002 VDD VDD sky130_fd_pr__pfet_01v8 w=1 l=0.15
  xm7 Out N002 0 0 sky130_fd_pr__nfet_01v8 w=0.5 l=0.15
  xm8 N003 N003 0 0 sky130_fd_pr__nfet_01v8 w=0.5 l=0.15
  xm9 N003 Vinm N001 VDD sky130_fd_pr__pfet_01v8 w=1 l=0.15
  xm10 N002 Vinp N001 VDD sky130_fd_pr__pfet_01v8 w=1 l=0.15
  xm11 N002 N003 0 0 sky130_fd_pr__nfet_01v8 w=0.5 l=0.15
  xm12 N001 N003 VDD VDD sky130_fd_pr__pfet_01v8 w=1 l=0.15
.ends Fig_18_23

.control
tran 1p 100n

let power = v(VDD) * abs(i(VDD))
let avg_power = mean(power)
print avg_power

meas tran vout_max MAX v(out)
meas tran vout_min MIN v(out)
let vout_swing = vout_max - vout_min
print vout_swing

meas tran rise_time TRIG v(out) VAL='0.1*vout_max' RISE=1 TARG v(out) VAL='0.9*vout_max' RISE=1
meas tran fall_time TRIG v(out) VAL='0.9*vout_max' FALL=1 TARG v(out) VAL='0.1*vout_max' FALL=1
print rise_time fall_time

quit
.endc

.end
