* Circuit: Chap26_LTspice/Fig26_4
.lib ${SKY130_PDK} tt

xmsu2 N002 N002 VDD VDD sky130_fd_pr__pfet_01v8 w=1 l=0.15
xmsu1 N002 Vbiasn 0 0 sky130_fd_pr__nfet_01v8 w=1.47 l=0.15
xmsu3 VDD N002 Vbiasn 0 sky130_fd_pr__nfet_01v8 w=1 l=0.15
xm3 Vbiasn Vbiasp VDD VDD sky130_fd_pr__pfet_01v8 w=1.47 l=0.15
xm4 N003 Vbiasp VDD VDD sky130_fd_pr__pfet_01v8 w=1.47 l=0.15
xm1 Vbiasn Vbiasn 0 0 sky130_fd_pr__nfet_01v8 w=1.47 l=0.15
R1 N004 0 4000.0
xma4 Vbiasp N001 VDD VDD sky130_fd_pr__pfet_01v8 w=1.47 l=0.15
xma3 N001 N001 VDD VDD sky130_fd_pr__pfet_01v8 w=1.47 l=0.15
xm5 N001 N003 0 0 sky130_fd_pr__nfet_01v8 w=1.47 l=0.15
xm7 VDD Vbiasp VDD VDD sky130_fd_pr__pfet_01v8 w=1.47 l=5
xm2 Vbiasp Vbiasn 0 0 sky130_fd_pr__nfet_01v8 w=1.47 l=0.15
xm6 N003 N003 N004 0 sky130_fd_pr__nfet_01v8 w=1.47 l=0.15
VDD VDD 0 5

.control
op

let vdd_current = abs(i(VDD))
let power_dc = vdd_current * 5.0
print power_dc

* Print all node voltages for diagnosis
print all

quit
.endc

.end
