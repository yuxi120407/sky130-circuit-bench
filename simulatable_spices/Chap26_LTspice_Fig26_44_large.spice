* Circuit: Chap26_LTspice/Fig26_44_large
.lib ${SKY130_PDK} tt

VDD VDD 0 1
xm2 N001 N001 N006 0 sky130_fd_pr__nfet_01v8 w=1.47 l=0.15
xm3 vodm N004 N002 VDD sky130_fd_pr__pfet_01v8 w=1.47 l=0.15
VCM VCM 0 500m
X_U1 Vbiasn Vbiasp VDD 0 Fig_26_3
xm6 N001 N004 N003 VDD sky130_fd_pr__pfet_01v8 w=1.47 l=0.15
xm7 vodp N004 N005 VDD sky130_fd_pr__pfet_01v8 w=1.47 l=0.15
xm8 N004 N004 VDD VDD sky130_fd_pr__pfet_01v8 w=1.47 l=0.15
xm9 N002 N001 VDD VDD sky130_fd_pr__pfet_01v8 w=1.47 l=0.15
xm10 N003 N001 VDD VDD sky130_fd_pr__pfet_01v8 w=1.47 l=0.15
xm11 N005 N001 VDD VDD sky130_fd_pr__pfet_01v8 w=1.47 l=0.15
xm12 vodp N001 ncr 0 sky130_fd_pr__nfet_01v8 w=1.47 l=0.15
xm13 vodm N001 ncl 0 sky130_fd_pr__nfet_01v8 w=1.47 l=0.15
xm5 N008 Vbiasn 0 0 sky130_fd_pr__nfet_01v8 w=1.47 l=0.15
xm14 N009 Vbiasn 0 0 sky130_fd_pr__nfet_01v8 w=1.47 l=0.15
xm15 N007 Vbiasn 0 0 sky130_fd_pr__nfet_01v8 w=1.47 l=0.15
xm16 N007 Vbiasn 0 0 sky130_fd_pr__nfet_01v8 w=1.47 l=0.15
xm17 ncr Vm N007 0 sky130_fd_pr__nfet_01v8 w=1.47 l=0.15
xm18 ncl Vp N007 0 sky130_fd_pr__nfet_01v8 w=1.47 l=0.15
xm19 N006 VCM N008 0 sky130_fd_pr__nfet_01v8 w=1.47 l=0.15
xm20 N004 VCM N009 0 sky130_fd_pr__nfet_01v8 w=1.47 l=0.15
xm21 vom vodp VDD VDD sky130_fd_pr__pfet_01v8 w=1.47 l=0.15
xm22 N012 vodm VDD VDD sky130_fd_pr__pfet_01v8 w=1.47 l=0.15
xm23 vom N012 N016 0 sky130_fd_pr__nfet_01v8 w=1.47 l=0.15
xm24 N012 N012 N015 0 sky130_fd_pr__nfet_01v8 w=1.47 l=0.15
C1 vom ncr 2.5e-14
xm25 vop vodm VDD VDD sky130_fd_pr__pfet_01v8 w=1.47 l=0.15
xm26 N013 vodp VDD VDD sky130_fd_pr__pfet_01v8 w=1.47 l=0.15
xm27 vop N013 N016 0 sky130_fd_pr__nfet_01v8 w=1.47 l=0.15
xm28 N013 N013 N014 0 sky130_fd_pr__nfet_01v8 w=1.47 l=0.15
C2 vop ncl 2.5e-14
R1 vop vcma 20000.0
R2 vcma vom 20000.0
C3 vop vcma 1e-14
C4 vcma vom 1e-14
xm29 N010 Vbiasp VDD VDD sky130_fd_pr__pfet_01v8 w=1.47 l=0.15
xm30 VCMFB N011 0 0 sky130_fd_pr__nfet_01v8 w=1.47 l=0.15
xm31 N011 N011 0 0 sky130_fd_pr__nfet_01v8 w=1.47 l=0.15
xm32 N011 vcma N010 VDD sky130_fd_pr__pfet_01v8 w=1.47 l=0.15
xm33 VCMFB VCM N010 VDD sky130_fd_pr__pfet_01v8 w=1.47 l=0.15
xm34 N016 VCMFB 0 0 sky130_fd_pr__nfet_01v8 w=1.47 l=0.15
xm35 N016 VCMFB 0 0 sky130_fd_pr__nfet_01v8 w=1.47 l=0.15
R3 vop vm 20000.0
R4 vm vip 20000.0
Vip1 vip 0 PULSE 700m 300m 0 500p 500p 4.5n 10n
R5 vom vp 20000.0
R6 vp vim 20000.0
Vip2 vim 0 PULSE 300m 700m 0 500p 500p 4.5n 10n
C5 vop 0 2.5e-13
C6 vom 0 2.5e-13
xm1 N014 Vbiasn 0 0 sky130_fd_pr__nfet_01v8 w=1.47 l=0.15
xm4 N015 Vbiasn 0 0 sky130_fd_pr__nfet_01v8 w=1.47 l=0.15
.subckt Fig_26_3 Vbiasn Vbiasp VDD GND
  xmsu2 N002 N002 VDD VDD sky130_fd_pr__pfet_01v8 w=1 l=0.15
  xmsu1 N002 Vbiasn GND 0 sky130_fd_pr__nfet_01v8 w=0.5 l=0.15
  xmsu3 Vbiasp N002 Vbiasn 0 sky130_fd_pr__nfet_01v8 w=1 l=0.15
  xm3 Vbiasn Vbiasp VDD VDD sky130_fd_pr__pfet_01v8 w=1 l=0.15
  xm4 N003 Vbiasp VDD VDD sky130_fd_pr__pfet_01v8 w=1 l=0.15
  xm1 Vbiasn Vbiasn 0 0 sky130_fd_pr__nfet_01v8 w=0.5 l=0.15
  R1 N004 0 4k
  xma4 Vbiasp N001 VDD VDD sky130_fd_pr__pfet_01v8 w=1 l=0.15
  xma3 N001 N001 VDD VDD sky130_fd_pr__pfet_01v8 w=1 l=0.15
  xm5 N001 N003 0 0 sky130_fd_pr__nfet_01v8 w=0.5 l=0.15
  xm7 VDD Vbiasp VDD VDD sky130_fd_pr__pfet_01v8 w=5 l=5
  xm2 Vbiasp Vbiasn 0 0 sky130_fd_pr__nfet_01v8 w=0.5 l=0.15
  xm6 N003 N003 N004 0 sky130_fd_pr__nfet_01v8 w=2 l=0.15
.ends Fig_26_3

.control
tran 1p 100n

let power = v(VDD) * abs(i(VDD))
let avg_power = mean(power)
print avg_power

meas tran vout_max MAX v(vop)
meas tran vout_min MIN v(vop)
let vout_swing = vout_max - vout_min
print vout_swing

meas tran rise_time TRIG v(vop) VAL='0.1*vout_max' RISE=1 TARG v(vop) VAL='0.9*vout_max' RISE=1
meas tran fall_time TRIG v(vop) VAL='0.9*vout_max' FALL=1 TARG v(vop) VAL='0.1*vout_max' FALL=1
print rise_time fall_time

quit
.endc

.end
