* CIRCUIT: _Extras_LTspice_Analog_3_stage_opamp_tran2
* YAML: /home/idies/workspace/Storage/xyu1/persistent/ALIGN-public/simple_circuit_5/OpenManus/autosizer_plus/circuits_yaml_generated/_Extras_LTspice__Analog__3_stage_opamp_tran2.yaml
* Variables: ['W_nfet_g0', 'W_nfet_g1', 'W_nfet_g2', 'W_nfet_g3', 'W_M14', 'W_M15', 'R1', 'R2', 'C1', 'C2', 'C3']
* Trial values (midpoint): [1.47, 1.47, 1.47, 1.47, 1.47, 1.47, 10000.0, 10000.0, 1e-11, 2.4e-13, 2.4e-13]
* Metrics: ['avg_power', 'vout_swing', 'rise_time', 'fall_time', 'fom']
* Class: mosfet_analog_tran
* FOM: 9.341554898076162e-19
* FIXED: node rename {'vout': 'out'}

* Circuit: _Extras_LTspice/Analog/3_stage_opamp_tran2
.lib ${SKY130_PDK} tt

VDD VDD 0 1
xm2 fbr VCM N002 0 sky130_fd_pr__nfet_01v8 w=1.47 l=0.15
xm1 fbl Vm N002 0 sky130_fd_pr__nfet_01v8 w=1.47 l=0.15
xm4 out12 out11 VDD VDD sky130_fd_pr__pfet_01v8 w=1.47 l=0.15
xm3 out11 out11 VDD VDD sky130_fd_pr__pfet_01v8 w=1.47 l=0.15
xm6t N002 Vbiasn 0 0 sky130_fd_pr__nfet_01v8 w=1.47 l=0.15
VCM VCM 0 500m AC 1
X_U1 Vbiasn Vbiasp VDD 0 Fig_26_3
xm5 N002 Vbiasn 0 0 sky130_fd_pr__nfet_01v8 w=1.47 l=0.15
xm6 N001 Vbiasp VDD VDD sky130_fd_pr__pfet_01v8 w=1.47 l=0.15
xm7 N001 Vbiasp VDD VDD sky130_fd_pr__pfet_01v8 w=1.47 l=0.15
xm8 out12 VCM fbr 0 sky130_fd_pr__nfet_01v8 w=1.47 l=0.15
xm9 out11 Vm fbl 0 sky130_fd_pr__nfet_01v8 w=1.47 l=0.15
xm10 Out22 N003 0 0 sky130_fd_pr__nfet_01v8 w=1.47 l=0.15
xm11 N003 N003 0 0 sky130_fd_pr__nfet_01v8 w=1.47 l=0.15
xm12 N003 Out12 N001 VDD sky130_fd_pr__pfet_01v8 w=1.47 l=0.15
xm13 Out22 Out11 N001 VDD sky130_fd_pr__pfet_01v8 w=1.47 l=0.15
xm14 out Out22 0 0 sky130_fd_pr__nfet_01v8 w=1.47 l=0.15
xm15 out Out12 VDD VDD sky130_fd_pr__pfet_01v8 w=1.47 l=0.15
C1 out 0 1e-11
C2 out fbr 2.4e-13
C3 Out22 fbl 2.4e-13
R1 Vm out 10000.0
R2 Vin Vm 10000.0
Vin Vin 0 PULSE(100m 900m 480n 100p 100p 50n)
.subckt Fig_26_3 Vbiasn Vbiasp VDD GND
  xmsu2 N002 N002 VDD VDD sky130_fd_pr__pfet_01v8 w=1 l=0.15
  xmsu1 N002 Vbiasn GND 0 sky130_fd_pr__nfet_01v8 w=0.5 l=0.15
  xmsu3 Vbiasp N002 Vbiasn 0 sky130_fd_pr__nfet_01v8 w=1 l=0.15
  xm3 Vbiasn Vbiasp VDD VDD sky130_fd_pr__pfet_01v8 w=1 l=0.15
  xm4 N003 Vbiasp VDD VDD sky130_fd_pr__pfet_01v8 w=1 l=0.15
  xm1 Vbiasn Vbiasn 0 0 sky130_fd_pr__nfet_01v8 w=0.5 l=0.15
  R1 N004 0 4k
  xma4 Vbiasp N001 VDD VDD sky130_fd_pr__pfet_01v8 w=1 l=0.15
  xma3 N001 N001 VDD VDD sky130_fd_pr__pfet_01v8 w=1 l=0.15
  xm5 N001 N003 0 0 sky130_fd_pr__nfet_01v8 w=0.5 l=0.15
  xm7 VDD Vbiasp VDD VDD sky130_fd_pr__pfet_01v8 w=5 l=5
  xm2 Vbiasp Vbiasn 0 0 sky130_fd_pr__nfet_01v8 w=0.5 l=0.15
  xm6 N003 N003 N004 0 sky130_fd_pr__nfet_01v8 w=2 l=0.15
.ends Fig_26_3

.control
tran 1p 100n

let power = v(VDD) * abs(i(VDD))
let avg_power = mean(power)
print avg_power

meas tran vout_max MAX v(out)
meas tran vout_min MIN v(out)
let vout_swing = vout_max - vout_min
print vout_swing

meas tran rise_time TRIG v(out) VAL='0.1*vout_max' RISE=1 TARG v(out) VAL='0.9*vout_max' RISE=1
meas tran fall_time TRIG v(out) VAL='0.9*vout_max' FALL=1 TARG v(out) VAL='0.1*vout_max' FALL=1
print rise_time fall_time

quit
.endc

.end
