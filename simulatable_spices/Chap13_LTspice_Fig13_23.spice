* Circuit: Chap13_LTspice/Fig13_23
.lib ${SKY130_PDK} tt

xm1 N004 N002 0 0 sky130_fd_pr__nfet_01v8 w=1.47 l=0.15
VDD VDD 0 1
xm2 N004 N002 VDD VDD sky130_fd_pr__pfet_01v8 w=1.47 l=0.15
xm5 N003 N004 0 0 sky130_fd_pr__nfet_01v8 w=1.47 l=0.15
xm6 N003 N004 VDD VDD sky130_fd_pr__pfet_01v8 w=1.47 l=0.15
xm7 D clock_b N002 0 sky130_fd_pr__nfet_01v8 w=1.47 l=0.15
VD D 0 PULSE 0 1 300p 10p 10p 700p 1.9n
Vclock_b clock_b 0 PULSE 1 0 0 10p 10p 1.1n 2.2n
Vclock clock 0 PULSE 0 1 0 10p 10p 1.1n 2.2n
xm3 N002 clock D VDD sky130_fd_pr__pfet_01v8 w=1.47 l=0.15
xm4 N002 clock N003 0 sky130_fd_pr__nfet_01v8 w=1.47 l=0.15
xm8 N003 clock_b N002 VDD sky130_fd_pr__pfet_01v8 w=1.47 l=0.15
xm9 Q N001 0 0 sky130_fd_pr__nfet_01v8 w=1.47 l=0.15
xm10 Q N001 VDD VDD sky130_fd_pr__pfet_01v8 w=1.47 l=0.15
xm11 Q_bar Q 0 0 sky130_fd_pr__nfet_01v8 w=1.47 l=0.15
xm12 Q_bar Q VDD VDD sky130_fd_pr__pfet_01v8 w=1.47 l=0.15
xm13 N004 clock N001 0 sky130_fd_pr__nfet_01v8 w=1.47 l=0.15
xm14 N001 clock_b N004 VDD sky130_fd_pr__pfet_01v8 w=1.47 l=0.15
xm15 N001 clock_b Q_bar 0 sky130_fd_pr__nfet_01v8 w=1.47 l=0.15
xm16 Q_bar clock N001 VDD sky130_fd_pr__pfet_01v8 w=1.47 l=0.15

.control
op

let vdd_current = abs(i(VDD))
let power_dc = vdd_current * 1.0
print power_dc

* Print all node voltages for diagnosis
print all

quit
.endc

.end
