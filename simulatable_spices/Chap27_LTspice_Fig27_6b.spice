* Circuit: Chap27_LTspice/Fig27_6b
.lib ${SKY130_PDK} tt

VDD VDD 0 5
xmsu3 N003 Vbiasn 0 0 sky130_fd_pr__nfet_01v8 w=1.47 l=2
xm31 N002 N002 VDD VDD sky130_fd_pr__pfet_01v8 w=1.47 l=2
xm41 N001 N001 VDD VDD sky130_fd_pr__pfet_01v8 w=1.47 l=2
xm2 N001 vm N003 0 sky130_fd_pr__nfet_01v8 w=1.47 l=2
xm1 N002 vp N003 0 sky130_fd_pr__nfet_01v8 w=1.47 l=2
X_U1 Vbiasn Vbiasp VDD 0 Fig_20_15
Vp vp 0 2.5
Vm vm 0 2.5
xm3 vop N002 VDD VDD sky130_fd_pr__pfet_01v8 w=1.47 l=2
xm4 vom N001 VDD VDD sky130_fd_pr__pfet_01v8 w=1.47 l=2
xm5 vop vop 0 0 sky130_fd_pr__nfet_01v8 w=1.47 l=2
xm6 vop vom 0 0 sky130_fd_pr__nfet_01v8 w=1.47 l=2
xm7 vom vop 0 0 sky130_fd_pr__nfet_01v8 w=1.47 l=2
xm8 vom vom 0 0 sky130_fd_pr__nfet_01v8 w=1.47 l=2
.subckt Fig_20_15 Vbiasn Vbiasp VDD GND
  xmsu2 N001 N001 VDD VDD sky130_fd_pr__pfet_01v8 w=10 l=20
  xmsu1 N001 Vbiasn 0 0 sky130_fd_pr__nfet_01v8 w=10 l=2
  xmsu3 VDD N001 Vbiasn 0 sky130_fd_pr__nfet_01v8 w=10 l=1
  xm3 Vbiasn Vbiasp VDD VDD sky130_fd_pr__pfet_01v8 w=30 l=2
  xm4 Vbiasp Vbiasp VDD VDD sky130_fd_pr__pfet_01v8 w=30 l=2
  xm1 Vbiasn Vbiasn 0 0 sky130_fd_pr__nfet_01v8 w=10 l=2
  xm2 Vbiasp Vbiasn N002 0 sky130_fd_pr__nfet_01v8 w=40 l=2
  R1 N002 GND 6.5k
.ends Fig_20_15

.control
op

let vdd_current = abs(i(VDD))
let power_dc = vdd_current * 5.0
print power_dc

* Print all node voltages for diagnosis
print all

quit
.endc

.end
