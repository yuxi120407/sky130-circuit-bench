* Circuit: Chap13_LTspice/Fig13_21
.lib ${SKY130_PDK} tt

xm1 Q_bar N001 0 0 sky130_fd_pr__nfet_01v8 w=1.47 l=0.15
VDD VDD 0 1
xm2 Q_bar N001 VDD VDD sky130_fd_pr__pfet_01v8 w=1.47 l=0.15
xm5 Q Q_bar 0 0 sky130_fd_pr__nfet_01v8 w=1.47 l=0.15
xm6 Q Q_bar VDD VDD sky130_fd_pr__pfet_01v8 w=1.47 l=0.15
xm7 D clock N001 0 sky130_fd_pr__nfet_01v8 w=1.47 l=0.15
VD D 0 PULSE 0 1 500p 10p 10p 700p 1.9n
Vclock clock 0 PULSE 0 1 0 10p 10p 1n 2n
xm3 N001 clock_b D VDD sky130_fd_pr__pfet_01v8 w=1.47 l=0.15
xm4 N001 clock_b Q 0 sky130_fd_pr__nfet_01v8 w=1.47 l=0.15
xm8 Q clock N001 VDD sky130_fd_pr__pfet_01v8 w=1.47 l=0.15
Vclock1 clock_b 0 PULSE 1 0 0 10p 10p 1n 2n

.control
op

let vdd_current = abs(i(VDD))
let power_dc = vdd_current * 1.0
print power_dc

* Print all node voltages for diagnosis
print all

quit
.endc

.end
