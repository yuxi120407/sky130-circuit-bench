* CIRCUIT: Chap12_LTspice/Fig12_10
* YAML: /home/idies/workspace/Storage/xyu1/persistent/ALIGN-public/simple_circuit_5/OpenManus/autosizer_plus/circuits_yaml_generated/Chap12_LTspice__Fig12_10.yaml
* Variables: ['W_nfet_g0', 'W_nfet_g1', 'C1']
* Trial values (midpoint): [1.47, 1.47, 5e-14]
* Metrics: ['avg_power', 'vout_swing', 'rise_time', 'fall_time', 'fom']
* Class: mosfet_analog_tran

* Circuit: Chap12_LTspice/Fig12_10
.lib ${SKY130_PDK} tt

Vin Vin 0 PULSE 0 1 200p 1p 1p 1.5n
VDD VDD 0 1
xm4 Vout Vin VDD VDD sky130_fd_pr__pfet_01v8 w=1.47 l=0.15
xm1 P001 Vin 0 0 sky130_fd_pr__nfet_01v8 w=1.47 l=0.15
xm2 P002 Vin P001 0 sky130_fd_pr__nfet_01v8 w=1.47 l=0.15
xm3 Vout Vin P002 0 sky130_fd_pr__nfet_01v8 w=1.47 l=0.15
xm5 Vout Vin VDD VDD sky130_fd_pr__pfet_01v8 w=1.47 l=0.15
xm6 Vout Vin VDD VDD sky130_fd_pr__pfet_01v8 w=1.47 l=0.15
C1 Vout 0 5e-14

.control
tran 1p 100n

let power = v(VDD) * abs(i(VDD))
let avg_power = mean(power)
print avg_power

meas tran vout_max MAX v(vout)
meas tran vout_min MIN v(vout)
let vout_swing = vout_max - vout_min
print vout_swing

meas tran rise_time TRIG v(vout) VAL='0.1*vout_max' RISE=1 TARG v(vout) VAL='0.9*vout_max' RISE=1
meas tran fall_time TRIG v(vout) VAL='0.9*vout_max' FALL=1 TARG v(vout) VAL='0.1*vout_max' FALL=1
print rise_time fall_time

quit
.endc

.end
