* Circuit: Chap25_LTspice/Fig25_20
.lib ${SKY130_PDK} tt

Vphi1 phi1 0 PULSE(1 0 5n 0 0 5n 10n)
Vphi2 phi2 0 PULSE(1 0 5.2n 0 0 5n 10n)
Vphi3 phi3 0 PULSE(0 1 5.4n 0 0 4n 10n)
V1 Vinm 0 SINE(500m -100m 5MEG)
V2 Vinp 0 SINE(500m 100m 5MEG)
E1 vop N002 vp vm 1e6
E2 N002 vom vp vm 1e6
VCM N002 0 500mV
C1 vm N001 1e-12
C2 vp N003 1e-12
C3 voutp 0 1e-12
C4 voutm 0 1e-12
xm1 N001 phi2 vinp 0 sky130_fd_pr__nfet_01v8 w=1.47 l=0.15
xm2 N003 phi2 vinm 0 sky130_fd_pr__nfet_01v8 w=1.47 l=0.15
xm3 vop phi1 vm 0 sky130_fd_pr__nfet_01v8 w=1.47 l=0.15
xm4 vom phi1 vp 0 sky130_fd_pr__nfet_01v8 w=1.47 l=0.15
xm5 vop phi3 N001 0 sky130_fd_pr__nfet_01v8 w=1.47 l=0.15
xm6 N003 phi3 vom 0 sky130_fd_pr__nfet_01v8 w=1.47 l=0.15
xm7 voutp phi3 vop 0 sky130_fd_pr__nfet_01v8 w=1.47 l=0.15
xm8 vom phi3 voutm 0 sky130_fd_pr__nfet_01v8 w=1.47 l=0.15

.control
tran 1p 100n

let power = v(VDD) * abs(i(VDD))
let avg_power = mean(power)
print avg_power

meas tran vout_max MAX v(voutp)
meas tran vout_min MIN v(voutp)
let vout_swing = vout_max - vout_min
print vout_swing

meas tran rise_time TRIG v(voutp) VAL='0.1*vout_max' RISE=1 TARG v(voutp) VAL='0.9*vout_max' RISE=1
meas tran fall_time TRIG v(voutp) VAL='0.9*vout_max' FALL=1 TARG v(voutp) VAL='0.1*vout_max' FALL=1
print rise_time fall_time

quit
.endc

.end
