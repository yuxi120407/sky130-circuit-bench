* CIRCUIT: Chap12_LTspice/Fig12_5
* YAML: /home/idies/workspace/Storage/xyu1/persistent/ALIGN-public/simple_circuit_5/OpenManus/autosizer_plus/circuits_yaml_generated/Chap12_LTspice__Fig12_5.yaml
* Variables: ['W_pfet_g0', 'W_nfet_g1']
* Trial values (midpoint): [1.47, 1.47]
* Metrics: ['dc_gain_db', 'power_dc', 'fom']
* Class: mosfet_analog_dc

* Circuit: Chap12_LTspice/Fig12_5
.lib ${SKY130_PDK} tt

Vin Vin 0 0
VDD VDD 0 5
xm6 P001 Vin VDD VDD sky130_fd_pr__pfet_01v8 w=1.47 l=1
xm1 Vout Vin 0 0 sky130_fd_pr__nfet_01v8 w=1.47 l=1
xm2 Vout Vin 0 0 sky130_fd_pr__nfet_01v8 w=1.47 l=1
xm3 Vout Vin 0 0 sky130_fd_pr__nfet_01v8 w=1.47 l=1
xm5 P002 Vin P001 VDD sky130_fd_pr__pfet_01v8 w=1.47 l=1
xm4 Vout Vin P002 VDD sky130_fd_pr__pfet_01v8 w=1.47 l=1

.control
dc VIN 0 5.0 0.01

let vout_deriv = deriv(v(vout))
let gain_linear = abs(vout_deriv)
let gain_db = db(gain_linear)
meas dc dc_gain_db MAX gain_db

let vdd_current = abs(i(VDD))
let power_dc = mean(vdd_current) * 5.0
print dc_gain_db power_dc

quit
.endc

.end
