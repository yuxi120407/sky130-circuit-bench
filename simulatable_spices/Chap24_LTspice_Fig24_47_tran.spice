* CIRCUIT: Chap24_LTspice/Fig24_47_tran
* YAML: /home/idies/workspace/Storage/xyu1/persistent/ALIGN-public/simple_circuit_5/OpenManus/autosizer_plus/circuits_yaml_generated/Chap24_LTspice__Fig24_47_tran.yaml
* Variables: ['W_nfet_g0', 'W_nfet_g1', 'W_nfet_g2', 'W_nfet_g3', 'R1', 'R2', 'Cload1', 'Cc1']
* Trial values (midpoint): [1.47, 1.47, 1.47, 1.47, 10000.0, 10000.0, 1e-12, 2.4e-13]
* Metrics: ['avg_power', 'vout_swing', 'rise_time', 'fall_time', 'fom']
* Class: mosfet_analog_tran

* Circuit: Chap24_LTspice/Fig24_47_tran
.lib ${SKY130_PDK} tt

VDD VDD 0 1
X_U1 Vbias1 Vhigh Vbias2 Vpcas Vncas Vbias3 Vlow Vbias4 VDD 0 Fig_20_47
vp vp 0 500m AC 1
Vin1 Vin 0 PULSE(100m 900m 510n 10p 10p 40n 1u)
R1 Vm Vin 10000.0
R2 Vm Vout 10000.0
xm1 N003 N001 VDD VDD sky130_fd_pr__pfet_01v8 w=1.47 l=0.15
xm2 N002 vm N005 0 sky130_fd_pr__nfet_01v8 w=1.47 l=0.15
xm3 N003 vp N005 0 sky130_fd_pr__nfet_01v8 w=1.47 l=0.15
xm4 N005 Vbias3 N010 0 sky130_fd_pr__nfet_01v8 w=1.47 l=0.15
xm5 N010 Vbias4 0 0 sky130_fd_pr__nfet_01v8 w=1.47 l=0.15
xm6 N005 Vbias3 N009 0 sky130_fd_pr__nfet_01v8 w=1.47 l=0.15
xm7 N009 Vbias4 0 0 sky130_fd_pr__nfet_01v8 w=1.47 l=0.15
xm8 N007 Vbias3 N008 0 sky130_fd_pr__nfet_01v8 w=1.47 l=0.15
xm9 N008 N006 0 0 sky130_fd_pr__nfet_01v8 w=1.47 l=0.15
xm10 N006 Vbias3 N011 0 sky130_fd_pr__nfet_01v8 w=1.47 l=0.15
xm11 N011 N006 0 0 sky130_fd_pr__nfet_01v8 w=1.47 l=0.15
xm12 N003 N001 VDD VDD sky130_fd_pr__pfet_01v8 w=1.47 l=0.15
xm13 N002 N001 VDD VDD sky130_fd_pr__pfet_01v8 w=1.47 l=0.15
xm14 N002 N001 VDD VDD sky130_fd_pr__pfet_01v8 w=1.47 l=0.15
xm15 N004 Vbias2 N003 VDD sky130_fd_pr__pfet_01v8 w=1.47 l=0.15
xm16 N001 Vbias2 N002 VDD sky130_fd_pr__pfet_01v8 w=1.47 l=0.15
Cload1 Vout 0 1e-12
xmfcpl1 N006 Vpcas N001 VDD sky130_fd_pr__pfet_01v8 w=1.47 l=0.15
xmfcpr1 N007 Vpcas N004 VDD sky130_fd_pr__pfet_01v8 w=1.47 l=0.15
xmfcnr1 N004 Vncas N007 0 sky130_fd_pr__nfet_01v8 w=1.47 l=0.15
xmfcnl1 N001 Vncas N006 0 sky130_fd_pr__nfet_01v8 w=1.47 l=0.15
xmop1 Vout N004 VDD VDD sky130_fd_pr__pfet_01v8 w=1.47 l=0.15
xmon1 Vout N007 0 0 sky130_fd_pr__nfet_01v8 w=1.47 l=0.15
Cc1 Vout N008 2.4e-13
.subckt Fig_20_47 Vbias1 Vhigh Vbias2 Vpcas Vncas Vbias3 Vlow Vbias4 VDD GND
  xmsu2 N002 N002 VDD VDD sky130_fd_pr__pfet_01v8 w=1 l=0.15
  xmsu1 N002 N003 0 0 sky130_fd_pr__nfet_01v8 w=1 l=0.15
  xmsu3 Vbiasp N002 N003 0 sky130_fd_pr__nfet_01v8 w=1 l=0.15
  xm3 N003 Vbiasp VDD VDD sky130_fd_pr__pfet_01v8 w=5 l=0.15
  xm4 N004 Vbiasp VDD VDD sky130_fd_pr__pfet_01v8 w=5 l=0.15
  xm1 N003 N003 0 0 sky130_fd_pr__nfet_01v8 w=1 l=0.15
  xm2 N004 N004 N005 0 sky130_fd_pr__nfet_01v8 w=1 l=0.15
  R1 N005 GND 5.5k
  xma4 Vbiasp N001 VDD VDD sky130_fd_pr__pfet_01v8 w=5 l=0.15
  xma3 N001 N001 VDD VDD sky130_fd_pr__pfet_01v8 w=5 l=0.15
  xm5 N001 N004 0 0 sky130_fd_pr__nfet_01v8 w=1 l=0.15
  xm6 Vbiasp N003 0 0 sky130_fd_pr__nfet_01v8 w=1 l=0.15
  xm7 VDD Vbiasp VDD VDD sky130_fd_pr__pfet_01v8 w=5 l=5
  xma1 Vbias3 Vbiasp VDD VDD sky130_fd_pr__pfet_01v8 w=5 l=0.15
  xma2 Vbias4 Vbiasp VDD VDD sky130_fd_pr__pfet_01v8 w=5 l=0.15
  xmsu4 Vbias3 Vbias3 0 0 sky130_fd_pr__nfet_01v8 w=0.5 l=0.5
  xm8 Vbias4 Vbias3 Vlow 0 sky130_fd_pr__nfet_01v8 w=1 l=0.15
  xm9 Vlow Vbias4 0 0 sky130_fd_pr__nfet_01v8 w=1 l=0.15
  xm10 Vpcas Vbias3 N009 0 sky130_fd_pr__nfet_01v8 w=1 l=0.15
  xm11 N009 Vbias4 0 0 sky130_fd_pr__nfet_01v8 w=1 l=0.15
  xm12 Vbias2 Vbias3 N010 0 sky130_fd_pr__nfet_01v8 w=1 l=0.15
  xm13 N010 Vbias4 0 0 sky130_fd_pr__nfet_01v8 w=1 l=0.15
  xm14 Vbias1 Vbias3 N011 0 sky130_fd_pr__nfet_01v8 w=1 l=0.15
  xm15 N011 Vbias4 0 0 sky130_fd_pr__nfet_01v8 w=1 l=0.15
  xma5 Vpcas Vpcas N006 VDD sky130_fd_pr__pfet_01v8 w=5 l=0.15
  xma6 N006 Vbias2 N007 VDD sky130_fd_pr__pfet_01v8 w=5 l=0.15
  xma7 N007 N006 VDD VDD sky130_fd_pr__pfet_01v8 w=5 l=0.15
  xma8 Vbias2 Vbias2 VDD VDD sky130_fd_pr__pfet_01v8 w=1 l=0.5
  xma9 Vbias1 Vbias2 Vhigh VDD sky130_fd_pr__pfet_01v8 w=5 l=0.15
  xma10 Vhigh Vbias1 VDD VDD sky130_fd_pr__pfet_01v8 w=5 l=0.15
  xma11 Vncas Vbias2 N008 VDD sky130_fd_pr__pfet_01v8 w=5 l=0.15
  xma12 N008 Vbias1 VDD VDD sky130_fd_pr__pfet_01v8 w=5 l=0.15
  xm16 Vncas Vncas N012 0 sky130_fd_pr__nfet_01v8 w=1 l=0.15
  xm17 N012 Vbias3 P001 0 sky130_fd_pr__nfet_01v8 w=1 l=0.15
  xm18 P001 N012 0 0 sky130_fd_pr__nfet_01v8 w=1 l=0.15
.ends Fig_20_47

.control
tran 1p 100n

let power = v(VDD) * abs(i(VDD))
let avg_power = mean(power)
print avg_power

meas tran vout_max MAX v(vout)
meas tran vout_min MIN v(vout)
let vout_swing = vout_max - vout_min
print vout_swing

meas tran rise_time TRIG v(vout) VAL='0.1*vout_max' RISE=1 TARG v(vout) VAL='0.9*vout_max' RISE=1
meas tran fall_time TRIG v(vout) VAL='0.9*vout_max' FALL=1 TARG v(vout) VAL='0.1*vout_max' FALL=1
print rise_time fall_time

quit
.endc

.end
