* Circuit: Chap14_LTspice/Fig14_7
.lib ${SKY130_PDK} tt

xm1 Q_bar stor 0 0 sky130_fd_pr__nfet_01v8 w=1.47 l=0.15
VDD VDD 0 1
xm2 Q_bar stor VDD VDD sky130_fd_pr__pfet_01v8 w=1.47 l=0.15
xm3 Q Q_bar 0 0 sky130_fd_pr__nfet_01v8 w=1.47 l=0.15
xm4 Q Q_bar VDD VDD sky130_fd_pr__pfet_01v8 w=1.47 l=0.15
xm5 0 0 stor 0 sky130_fd_pr__nfet_01v8 w=1.47 l=0.15

.control
op

let vdd_current = abs(i(VDD))
let power_dc = vdd_current * 1.0
print power_dc

* Print all node voltages for diagnosis
print all

quit
.endc

.end
