* CIRCUIT: Chap18_LTspice_Fig18_15
* YAML: /home/idies/workspace/Storage/xyu1/persistent/ALIGN-public/simple_circuit_5/OpenManus/autosizer_plus/circuits_yaml_generated/Chap18_LTspice__Fig18_15.yaml
* Variables: ['W_nfet_g0', 'W_nfet_g1', 'C1', 'C2']
* Trial values (midpoint): [1.47, 1.47, 5e-14, 5e-14]
* Metrics: ['avg_power', 'vout_swing', 'rise_time', 'fall_time', 'fom']
* Class: mosfet_analog_tran
* FOM: 3.8171612407104834e-08
* FIXED: node rename {'vout': 'Outa'}

* Circuit: Chap18_LTspice/Fig18_15
.lib ${SKY130_PDK} tt

xm1 N001 A 0 0 sky130_fd_pr__nfet_01v8 w=1.47 l=0.15
VA A 0 PULSE(0 1 0 1n 1n 100n)
VDD VDD 0 1
xm2 Outa A VDD VDD sky130_fd_pr__pfet_01v8 w=1.47 l=0.15
xm3 Outa B VDD VDD sky130_fd_pr__pfet_01v8 w=1.47 l=0.15
xm4 Outa B N001 0 sky130_fd_pr__nfet_01v8 w=1.47 l=0.15
xm5 N002 B 0 0 sky130_fd_pr__nfet_01v8 w=1.47 l=0.15
xm6 Outb B VDD VDD sky130_fd_pr__pfet_01v8 w=1.47 l=0.15
xm7 Outb A VDD VDD sky130_fd_pr__pfet_01v8 w=1.47 l=0.15
xm8 Outb A N002 0 sky130_fd_pr__nfet_01v8 w=1.47 l=0.15
VB B 0 1
C1 Outa 0 5e-14
C2 Outb 0 5e-14

.control
tran 1p 100n

let power = v(VDD) * abs(i(VDD))
let avg_power = mean(power)
print avg_power

meas tran vout_max MAX v(Outa)
meas tran vout_min MIN v(Outa)
let vout_swing = vout_max - vout_min
print vout_swing

meas tran rise_time TRIG v(Outa) VAL='0.1*vout_max' RISE=1 TARG v(Outa) VAL='0.9*vout_max' RISE=1
meas tran fall_time TRIG v(Outa) VAL='0.9*vout_max' FALL=1 TARG v(Outa) VAL='0.1*vout_max' FALL=1
print rise_time fall_time

quit
.endc

.end
