* CIRCUIT: Chap10_LTspice/Fig10_23
* YAML: /home/idies/workspace/Storage/xyu1/persistent/ALIGN-public/simple_circuit_5/OpenManus/autosizer_plus/circuits_yaml_generated/Chap10_LTspice__Fig10_23.yaml
* Variables: ['W_nfet_g0', 'C1']
* Trial values (midpoint): [1.47, 5e-14]
* Metrics: ['avg_power', 'vout_swing', 'rise_time', 'fall_time', 'fom']
* Class: mosfet_analog_tran

* Circuit: Chap10_LTspice/Fig10_23
.lib ${SKY130_PDK} tt

xm1 N001 VDD Vin 0 sky130_fd_pr__nfet_01v8 w=1.47 l=0.15
Vin Vin 0 PULSE 0 1 5n 100p 100p 5n 30n
C1 Vout 0 5e-14
VDD VDD 0 1
xm2 N002 VDD N001 0 sky130_fd_pr__nfet_01v8 w=1.47 l=0.15
xm3 N003 VDD N002 0 sky130_fd_pr__nfet_01v8 w=1.47 l=0.15
xm4 N004 VDD N003 0 sky130_fd_pr__nfet_01v8 w=1.47 l=0.15
xm5 N005 VDD N004 0 sky130_fd_pr__nfet_01v8 w=1.47 l=0.15
xm6 N006 VDD N005 0 sky130_fd_pr__nfet_01v8 w=1.47 l=0.15
xm7 N007 VDD N006 0 sky130_fd_pr__nfet_01v8 w=1.47 l=0.15
xm8 N008 VDD N007 0 sky130_fd_pr__nfet_01v8 w=1.47 l=0.15
xm9 N009 VDD N008 0 sky130_fd_pr__nfet_01v8 w=1.47 l=0.15
xm10 Vout VDD N009 0 sky130_fd_pr__nfet_01v8 w=1.47 l=0.15

.control
tran 1p 100n

let power = v(VDD) * abs(i(VDD))
let avg_power = mean(power)
print avg_power

meas tran vout_max MAX v(vout)
meas tran vout_min MIN v(vout)
let vout_swing = vout_max - vout_min
print vout_swing

meas tran rise_time TRIG v(vout) VAL='0.1*vout_max' RISE=1 TARG v(vout) VAL='0.9*vout_max' RISE=1
meas tran fall_time TRIG v(vout) VAL='0.9*vout_max' FALL=1 TARG v(vout) VAL='0.1*vout_max' FALL=1
print rise_time fall_time

quit
.endc

.end
