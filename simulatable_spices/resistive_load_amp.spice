* CIRCUIT: resistive_load_amp
* YAML: /home/idies/workspace/Storage/xyu1/persistent/ALIGN-public/simple_circuit_5/OpenManus/autosizer_plus/circuits_yaml/resistive_load_amp.yaml
* Variables: ['W_input', 'L_input', 'R_load']
* Trial values (midpoint): [20, 2.0, '50e3']
* Metrics: ['gain_db', 'bandwidth_mhz', 'power_uw', 'output_swing_v', 'fom']
* Class: unknown

* Resistive Load Amplifier Testbench
.lib ${SKY130_PDK} tt
.global VDD GND
.temp 27

* Resistive Load Amplifier
* Input transistor (NMOS common-source)
XM1 VOUT VIN GND GND sky130_fd_pr__nfet_01v8 l=2.0 w=20

* Load resistor
RL VDD VOUT 50e3

* Load capacitor
CL VOUT GND 10e-15

* DC bias + AC signal
VIN VIN GND DC 0.6 AC 0.001

* Supply
VDD VDD GND DC 1.8

.control
set noaskquit
op
let power_uw = abs(i(VDD)) * 1.8 * 1e6
print power_uw

ac dec 100 1 10g
let gain_db = db(vm(VOUT)) - db(0.001)
let dc_gain_db = gain_db[0]
print dc_gain_db

meas ac bw WHEN gain_db=dc_gain_db-3 CROSS=1
let bandwidth_mhz = bw / 1e6
print bandwidth_mhz

let output_swing_v = 0
print output_swing_v

quit
.endc

.end
