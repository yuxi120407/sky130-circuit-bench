* Circuit: Chap20_LTspice/Fig20_48
.lib ${SKY130_PDK} tt

VDD VDD 0 1
xm2 N003 Vbias4 0 0 sky130_fd_pr__nfet_01v8 w=1.47 l=0.15
Vo N002 0 0
xmn N002 Vbias3 N003 0 sky130_fd_pr__nfet_01v8 w=1.47 l=0.15
xm6b N001 Vbias1 VDD VDD sky130_fd_pr__pfet_01v8 w=1.47 l=0.15
xmp N002 Vbias2 N001 VDD sky130_fd_pr__pfet_01v8 w=1.47 l=0.15
X_U1 Vbias1 Vhigh Vbias2 Vpcas Vncas Vbias3 Vlow Vbias4 VDD 0 Fig_20_47
.subckt Fig_20_47 Vbias1 Vhigh Vbias2 Vpcas Vncas Vbias3 Vlow Vbias4 VDD GND
  xmsu2 N002 N002 VDD VDD sky130_fd_pr__pfet_01v8 w=1 l=0.15
  xmsu1 N002 N003 0 0 sky130_fd_pr__nfet_01v8 w=1 l=0.15
  xmsu3 Vbiasp N002 N003 0 sky130_fd_pr__nfet_01v8 w=1 l=0.15
  xm3 N003 Vbiasp VDD VDD sky130_fd_pr__pfet_01v8 w=5 l=0.15
  xm4 N004 Vbiasp VDD VDD sky130_fd_pr__pfet_01v8 w=5 l=0.15
  xm1 N003 N003 0 0 sky130_fd_pr__nfet_01v8 w=1 l=0.15
  xm2 N004 N004 N005 0 sky130_fd_pr__nfet_01v8 w=1 l=0.15
  R1 N005 GND 5.5k
  xma4 Vbiasp N001 VDD VDD sky130_fd_pr__pfet_01v8 w=5 l=0.15
  xma3 N001 N001 VDD VDD sky130_fd_pr__pfet_01v8 w=5 l=0.15
  xm5 N001 N004 0 0 sky130_fd_pr__nfet_01v8 w=1 l=0.15
  xm6 Vbiasp N003 0 0 sky130_fd_pr__nfet_01v8 w=1 l=0.15
  xm7 VDD Vbiasp VDD VDD sky130_fd_pr__pfet_01v8 w=5 l=5
  xma1 Vbias3 Vbiasp VDD VDD sky130_fd_pr__pfet_01v8 w=5 l=0.15
  xma2 Vbias4 Vbiasp VDD VDD sky130_fd_pr__pfet_01v8 w=5 l=0.15
  xmsu4 Vbias3 Vbias3 0 0 sky130_fd_pr__nfet_01v8 w=0.5 l=0.5
  xm8 Vbias4 Vbias3 Vlow 0 sky130_fd_pr__nfet_01v8 w=1 l=0.15
  xm9 Vlow Vbias4 0 0 sky130_fd_pr__nfet_01v8 w=1 l=0.15
  xm10 Vpcas Vbias3 N009 0 sky130_fd_pr__nfet_01v8 w=1 l=0.15
  xm11 N009 Vbias4 0 0 sky130_fd_pr__nfet_01v8 w=1 l=0.15
  xm12 Vbias2 Vbias3 N010 0 sky130_fd_pr__nfet_01v8 w=1 l=0.15
  xm13 N010 Vbias4 0 0 sky130_fd_pr__nfet_01v8 w=1 l=0.15
  xm14 Vbias1 Vbias3 N011 0 sky130_fd_pr__nfet_01v8 w=1 l=0.15
  xm15 N011 Vbias4 0 0 sky130_fd_pr__nfet_01v8 w=1 l=0.15
  xma5 Vpcas Vpcas N006 VDD sky130_fd_pr__pfet_01v8 w=5 l=0.15
  xma6 N006 Vbias2 N007 VDD sky130_fd_pr__pfet_01v8 w=5 l=0.15
  xma7 N007 N006 VDD VDD sky130_fd_pr__pfet_01v8 w=5 l=0.15
  xma8 Vbias2 Vbias2 VDD VDD sky130_fd_pr__pfet_01v8 w=1 l=0.5
  xma9 Vbias1 Vbias2 Vhigh VDD sky130_fd_pr__pfet_01v8 w=5 l=0.15
  xma10 Vhigh Vbias1 VDD VDD sky130_fd_pr__pfet_01v8 w=5 l=0.15
  xma11 Vncas Vbias2 N008 VDD sky130_fd_pr__pfet_01v8 w=5 l=0.15
  xma12 N008 Vbias1 VDD VDD sky130_fd_pr__pfet_01v8 w=5 l=0.15
  xm16 Vncas Vncas N012 0 sky130_fd_pr__nfet_01v8 w=1 l=0.15
  xm17 N012 Vbias3 P001 0 sky130_fd_pr__nfet_01v8 w=1 l=0.15
  xm18 P001 N012 0 0 sky130_fd_pr__nfet_01v8 w=1 l=0.15
.ends Fig_20_47

.control
dc Vo 0 1.0 0.005

let iout = abs(i(Vo))
let iout_deriv = deriv(iout)
let rout = 1.0 / abs(iout_deriv)

meas dc iout_mid FIND iout AT=0.5
meas dc rout_mid FIND rout AT=0.5

let vdd_current = abs(i(VDD))
let power_dc = mean(vdd_current) * 1.0
print iout_mid rout_mid power_dc

quit
.endc

.end
