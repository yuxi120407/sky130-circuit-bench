* Circuit: Chap18_LTspice/Fig18_39
.lib ${SKY130_PDK} tt

xm1i N001 N003 0 0 sky130_fd_pr__nfet_01v8 w=1.47 l=0.15
Vin N003 0 PULSE(1 0 0 10p 10p 5ns 10ns)
VDD VDD 0 1
xm2i N001 N003 VDD VDD sky130_fd_pr__pfet_01v8 w=1.47 l=0.15
Cload Vout 0 1e-12
C2 N002 B 1e-12
xm1a N002 N001 0 0 sky130_fd_pr__nfet_01v8 w=1.47 l=0.15
xm2a N002 N001 VDD VDD sky130_fd_pr__pfet_01v8 w=1.47 l=0.15
xm3 Vout N001 0 0 sky130_fd_pr__nfet_01v8 w=1.47 l=0.15
xm4 Vout N001 B B sky130_fd_pr__pfet_01v8 w=1.47 l=0.15
C1 N001 A 1e-13
xm2 B A VDD 0 sky130_fd_pr__nfet_01v8 w=1.47 l=0.15
xm1 A B VDD 0 sky130_fd_pr__nfet_01v8 w=1.47 l=0.15

.control
tran 1p 100n

let power = v(VDD) * abs(i(VDD))
let avg_power = mean(power)
print avg_power

meas tran vout_max MAX v(vout)
meas tran vout_min MIN v(vout)
let vout_swing = vout_max - vout_min
print vout_swing

meas tran rise_time TRIG v(vout) VAL='0.1*vout_max' RISE=1 TARG v(vout) VAL='0.9*vout_max' RISE=1
meas tran fall_time TRIG v(vout) VAL='0.9*vout_max' FALL=1 TARG v(vout) VAL='0.1*vout_max' FALL=1
print rise_time fall_time

quit
.endc

.end
