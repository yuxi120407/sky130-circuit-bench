* Circuit: Chap18_LTspice/Fig18_24
.lib ${SKY130_PDK} tt

xm1 N004 Vinm N005 0 sky130_fd_pr__nfet_01v8 w=1.47 l=0.15
Vinp Vinp 0 0
VDD VDD 0 1
xm3 N004 N004 VDD VDD sky130_fd_pr__pfet_01v8 w=1.47 l=0.15
xm4 N002 N004 VDD VDD sky130_fd_pr__pfet_01v8 w=1.47 l=0.15
xm2 N002 Vinp N005 0 sky130_fd_pr__nfet_01v8 w=1.47 l=0.15
Vinm Vinm 0 200m
xm6 N005 N004 0 0 sky130_fd_pr__nfet_01v8 w=1.47 l=0.15
xm5 Vout N002 VDD VDD sky130_fd_pr__pfet_01v8 w=1.47 l=0.15
xm7 Vout N002 0 0 sky130_fd_pr__nfet_01v8 w=1.47 l=0.15
Cload Vout 0 5e-14
xm8 N003 N003 0 0 sky130_fd_pr__nfet_01v8 w=1.47 l=0.15
xm9 N003 Vinm N001 VDD sky130_fd_pr__pfet_01v8 w=1.47 l=0.15
xm10 N002 Vinp N001 VDD sky130_fd_pr__pfet_01v8 w=1.47 l=0.15
xm11 N002 N003 0 0 sky130_fd_pr__nfet_01v8 w=1.47 l=0.15
xm12 N001 N003 VDD VDD sky130_fd_pr__pfet_01v8 w=1.47 l=0.15

.control
op

let vdd_current = abs(i(VDD))
let power_dc = vdd_current * 1.0
print power_dc

* Print all node voltages for diagnosis
print all

quit
.endc

.end
