* CIRCUIT: Chap11_LTspice_Fig11_8
* YAML: /home/idies/workspace/Storage/xyu1/persistent/ALIGN-public/simple_circuit_5/OpenManus/autosizer_plus/circuits_yaml_generated/Chap11_LTspice__Fig11_8.yaml
* Variables: ['W_nfet_g0', 'W_M2', 'W_M4', 'W_M6']
* Trial values (midpoint): [1.47, 1.47, 1.47, 1.47]
* Metrics: ['dc_gain_db', 'power_dc', 'fom']
* Class: mosfet_analog_dc
* FOM: 0.04200799686766437
* FIXED: node rename {'vout': 'vout333'}

* Circuit: Chap11_LTspice/Fig11_8
.lib ${SKY130_PDK} tt

xm1 Vout1 Vin 0 0 sky130_fd_pr__nfet_01v8 w=1.47 l=1
Vin Vin 0 0
VDD VDD 0 5
xm2 Vout1 Vin VDD VDD sky130_fd_pr__pfet_01v8 w=1.47 l=1
xm3 Vout3 Vin 0 0 sky130_fd_pr__nfet_01v8 w=1.47 l=1
xm4 Vout3 Vin VDD VDD sky130_fd_pr__pfet_01v8 w=1.47 l=1
xm5 Vout333 Vin 0 0 sky130_fd_pr__nfet_01v8 w=1.47 l=1
xm6 Vout333 Vin VDD VDD sky130_fd_pr__pfet_01v8 w=1.47 l=1

.control
dc VIN 0 5.0 0.01

let vout_deriv = deriv(v(vout333))
let gain_linear = abs(vout_deriv)
let gain_db = db(gain_linear)
meas dc dc_gain_db MAX gain_db

let vdd_current = abs(i(VDD))
let power_dc = mean(vdd_current) * 5.0
print dc_gain_db power_dc

quit
.endc

.end
