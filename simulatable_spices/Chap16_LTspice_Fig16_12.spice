* Circuit: Chap16_LTspice/Fig16_12
.lib ${SKY130_PDK} tt

xm1 N001 sense_N 0 0 sky130_fd_pr__nfet_01v8 w=1.47 l=0.15
Veq Eq 0 PULSE(0 1 5n 10p 10p 4n)
VDD VDD 0 1
VDDby2 VDDby2 0 500mV
Vsn sense_N 0 PULSE(0 1 15n 10p 10p 100n)
xm2 bitline1 bitline0 N001 0 sky130_fd_pr__nfet_01v8 w=1.47 l=0.15
xm3 bitline0 bitline1 N001 0 sky130_fd_pr__nfet_01v8 w=1.47 l=0.15
xm4 bitline1 Eq bitline0 0 sky130_fd_pr__nfet_01v8 w=1.47 l=0.15
xm5 bitline0 Eq VDDby2 0 sky130_fd_pr__nfet_01v8 w=1.47 l=0.15
xm6 VDDby2 Eq bitline1 0 sky130_fd_pr__nfet_01v8 w=1.47 l=0.15
Ccol1 bitline1 0 1e-13
Ccol0 bitline0 0 1e-13
xm7 bitline0 ra0 mb0 0 sky130_fd_pr__nfet_01v8 w=1.47 l=0.15
Cmbit0 mb0 0 2e-14
xm8 bitline1 ra1 mb1 0 sky130_fd_pr__nfet_01v8 w=1.47 l=0.15
Cmbit1 mb1 0 2e-14
Vra0 ra0 0 PULSE(0 1.5 12n 10p 10p 100n)
Vsn1 ra1 0 0

.control
tran 1p 100n

let power = v(VDD) * abs(i(VDD))
let avg_power = mean(power)
print avg_power

meas tran vout_max MAX v(bitline1)
meas tran vout_min MIN v(bitline1)
let vout_swing = vout_max - vout_min
print vout_swing

meas tran rise_time TRIG v(bitline1) VAL='0.1*vout_max' RISE=1 TARG v(bitline1) VAL='0.9*vout_max' RISE=1
meas tran fall_time TRIG v(bitline1) VAL='0.9*vout_max' FALL=1 TARG v(bitline1) VAL='0.1*vout_max' FALL=1
print rise_time fall_time

quit
.endc

.end
