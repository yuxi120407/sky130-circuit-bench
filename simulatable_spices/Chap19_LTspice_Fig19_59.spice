* Circuit: Chap19_LTspice/Fig19_59
.lib ${SKY130_PDK} tt

xm1 N004 N004 0 0 sky130_fd_pr__nfet_01v8 w=1.47 l=0.15
Vindel Vindel 0 0
VDD VDD 0 1
xm3 N004 n2 N003 VDD sky130_fd_pr__pfet_01v8 w=1.47 l=0.15
xm4 Vrbias Vref N003 VDD sky130_fd_pr__pfet_01v8 w=1.47 l=0.15
xm2 Vrbias N004 0 0 sky130_fd_pr__nfet_01v8 w=1.47 l=0.15
xm5 N001 N001 VDD VDD sky130_fd_pr__pfet_01v8 w=1.47 l=0.15
xm7 n2 Vrbias 0 0 sky130_fd_pr__nfet_01v8 w=1.47 l=0.15
xm6 N003 N004 VDD VDD sky130_fd_pr__pfet_01v8 w=1.47 l=0.15
xmref N001 Vindel P001 0 sky130_fd_pr__nfet_01v8 w=1.47 l=0.15
R1 P001 0 10000.0
VREF VREF 0 500mV
xm8 N002 N001 VDD VDD sky130_fd_pr__pfet_01v8 w=1.47 l=0.15
xm9 n2 0 N002 VDD sky130_fd_pr__pfet_01v8 w=1.47 l=0.15
xm10 n2 n2 0 0 sky130_fd_pr__nfet_01v8 w=1.47 l=0.15

.control
op

let vdd_current = abs(i(VDD))
let power_dc = vdd_current * 1.0
print power_dc

* Print all node voltages for diagnosis
print all

quit
.endc

.end
