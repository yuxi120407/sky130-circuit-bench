* Circuit: Chap26_LTspice/Fig26_21
.lib ${SKY130_PDK} tt

VDD VDD 0 1
xm2 N001 N001 N006 0 sky130_fd_pr__nfet_01v8 w=1.47 l=0.15
xm1 N001 N001 N007 0 sky130_fd_pr__nfet_01v8 w=1.47 l=0.15
xm4 N001 Vbiasn N002 VDD sky130_fd_pr__pfet_01v8 w=1.47 l=0.15
xm3 vom Vbiasn N003 VDD sky130_fd_pr__pfet_01v8 w=1.47 l=0.15
VCM VCM 0 500m
X_U1 Vbiasn Vbiasp VDD 0 Fig_26_3
xm6 N001 Vbiasn N002 VDD sky130_fd_pr__pfet_01v8 w=1.47 l=0.15
xm7 vop Vbiasn N004 VDD sky130_fd_pr__pfet_01v8 w=1.47 l=0.15
xm8 N002 N001 VDD VDD sky130_fd_pr__pfet_01v8 w=1.47 l=0.15
xm9 N003 N001 VDD VDD sky130_fd_pr__pfet_01v8 w=1.47 l=0.15
xm10 N002 N001 VDD VDD sky130_fd_pr__pfet_01v8 w=1.47 l=0.15
xm11 N004 N001 VDD VDD sky130_fd_pr__pfet_01v8 w=1.47 l=0.15
xm12 vop N001 N008 0 sky130_fd_pr__nfet_01v8 w=1.47 l=0.15
xm13 vom N001 N005 0 sky130_fd_pr__nfet_01v8 w=1.47 l=0.15
xm5 N010 Vbiasn 0 0 sky130_fd_pr__nfet_01v8 w=1.47 l=0.15
xm14 N010 Vbiasn 0 0 sky130_fd_pr__nfet_01v8 w=1.47 l=0.15
xm15 N009 Vbiasn 0 0 sky130_fd_pr__nfet_01v8 w=1.47 l=0.15
xm16 N009 Vbiasn 0 0 sky130_fd_pr__nfet_01v8 w=1.47 l=0.15
xm17 N008 VCM N009 0 sky130_fd_pr__nfet_01v8 w=1.47 l=0.15
xm18 N005 Vinp N009 0 sky130_fd_pr__nfet_01v8 w=1.47 l=0.15
xm19 N006 Vinp N010 0 sky130_fd_pr__nfet_01v8 w=1.47 l=0.15
xm20 N007 VCM N010 0 sky130_fd_pr__nfet_01v8 w=1.47 l=0.15
Vinp Vinp 0 500m
.subckt Fig_26_3 Vbiasn Vbiasp VDD GND
  xmsu2 N002 N002 VDD VDD sky130_fd_pr__pfet_01v8 w=1 l=0.15
  xmsu1 N002 Vbiasn GND 0 sky130_fd_pr__nfet_01v8 w=0.5 l=0.15
  xmsu3 Vbiasp N002 Vbiasn 0 sky130_fd_pr__nfet_01v8 w=1 l=0.15
  xm3 Vbiasn Vbiasp VDD VDD sky130_fd_pr__pfet_01v8 w=1 l=0.15
  xm4 N003 Vbiasp VDD VDD sky130_fd_pr__pfet_01v8 w=1 l=0.15
  xm1 Vbiasn Vbiasn 0 0 sky130_fd_pr__nfet_01v8 w=0.5 l=0.15
  R1 N004 0 4k
  xma4 Vbiasp N001 VDD VDD sky130_fd_pr__pfet_01v8 w=1 l=0.15
  xma3 N001 N001 VDD VDD sky130_fd_pr__pfet_01v8 w=1 l=0.15
  xm5 N001 N003 0 0 sky130_fd_pr__nfet_01v8 w=0.5 l=0.15
  xm7 VDD Vbiasp VDD VDD sky130_fd_pr__pfet_01v8 w=5 l=5
  xm2 Vbiasp Vbiasn 0 0 sky130_fd_pr__nfet_01v8 w=0.5 l=0.15
  xm6 N003 N003 N004 0 sky130_fd_pr__nfet_01v8 w=2 l=0.15
.ends Fig_26_3

.control
op

let vdd_current = abs(i(VDD))
let power_dc = vdd_current * 1.0
print power_dc

* Print all node voltages for diagnosis
print all

quit
.endc

.end
