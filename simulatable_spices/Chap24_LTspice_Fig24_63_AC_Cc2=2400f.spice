* Circuit: Chap24_LTspice/Fig24_63_AC_Cc2=2400f
.lib ${SKY130_PDK} tt

VDD VDD 0 1
vp vp 0 500m AC 1
Cbig1 vm 0 1e-05
Rbig1 vm Vout 1000000.0
xm28 N001 N001 N004 VDD sky130_fd_pr__pfet_01v8 w=1.47 l=0.15
xm1 N010 Vbiasn 0 0 sky130_fd_pr__nfet_01v8 w=1.47 l=0.15
xm2 N010 Vbiasn 0 0 sky130_fd_pr__nfet_01v8 w=1.47 l=0.15
xm3 N001 vm N010 0 sky130_fd_pr__nfet_01v8 w=1.47 l=0.15
xm4 N009 vp N010 0 sky130_fd_pr__nfet_01v8 w=1.47 l=0.15
xm5 N004 N001 VDD VDD sky130_fd_pr__pfet_01v8 w=1.47 l=0.15
xm6 N009 N001 N005 VDD sky130_fd_pr__pfet_01v8 w=1.47 l=0.15
xm7 N005 N001 VDD VDD sky130_fd_pr__pfet_01v8 w=1.47 l=0.15
xm8 N002 N002 N006 VDD sky130_fd_pr__pfet_01v8 w=1.47 l=0.15
xm9 N011 Vbiasn 0 0 sky130_fd_pr__nfet_01v8 w=1.47 l=0.15
xm10 N011 Vbiasn 0 0 sky130_fd_pr__nfet_01v8 w=1.47 l=0.15
xm11 N002 N009 N011 0 sky130_fd_pr__nfet_01v8 w=1.47 l=0.15
xm12 N003 N001 N011 0 sky130_fd_pr__nfet_01v8 w=1.47 l=0.15
xm13 N006 N002 VDD VDD sky130_fd_pr__pfet_01v8 w=1.47 l=0.15
xm14 N003 N002 N007 VDD sky130_fd_pr__pfet_01v8 w=1.47 l=0.15
xm15 N007 N002 VDD VDD sky130_fd_pr__pfet_01v8 w=1.47 l=0.15
xm16 Vout Vbiasn 0 0 sky130_fd_pr__nfet_01v8 w=1.47 l=0.15
xm18 Vout N003 N008 VDD sky130_fd_pr__pfet_01v8 w=1.47 l=0.15
xm19 N008 N003 VDD VDD sky130_fd_pr__pfet_01v8 w=1.47 l=0.15
Cc1 N003 N001 2.4e-13
Cc2 Vout N005 2.4e-12
X_U1 Vbiasn Vbiasp VDD 0 Fig_20_22
Cload Vout 0 1e-12
.subckt Fig_20_22 Vbiasn Vbiasp VDD GND
  xmsu2 N002 N002 VDD VDD sky130_fd_pr__pfet_01v8 w=1 l=0.15
  xmsu1 N002 Vbiasn GND 0 sky130_fd_pr__nfet_01v8 w=1 l=0.15
  xmsu3 Vbiasp N002 Vbiasn 0 sky130_fd_pr__nfet_01v8 w=1 l=0.15
  xm3 Vbiasn Vbiasp VDD VDD sky130_fd_pr__pfet_01v8 w=5 l=0.15
  xm4 N003 Vbiasp VDD VDD sky130_fd_pr__pfet_01v8 w=5 l=0.15
  xm1 Vbiasn Vbiasn 0 0 sky130_fd_pr__nfet_01v8 w=1 l=0.15
  R1 N004 0 5.5k
  xma4 Vbiasp N001 VDD VDD sky130_fd_pr__pfet_01v8 w=5 l=0.15
  xma3 N001 N001 VDD VDD sky130_fd_pr__pfet_01v8 w=5 l=0.15
  xm5 N001 N003 0 0 sky130_fd_pr__nfet_01v8 w=1 l=0.15
  xm7 VDD Vbiasp VDD VDD sky130_fd_pr__pfet_01v8 w=5 l=5
  xm8 0 Vbiasn 0 0 sky130_fd_pr__nfet_01v8 w=5 l=5
  xm2 Vbiasp Vbiasn 0 0 sky130_fd_pr__nfet_01v8 w=1 l=0.15
  xm6 N003 N003 N004 0 sky130_fd_pr__nfet_01v8 w=10 l=0.15
.ends Fig_20_22

.control
op
let vdd_current = abs(i(VDD))
let power_dc = vdd_current * 1.0
print power_dc

ac dec 100 1 10g
let vout_mag = vm(Vout)
let gain_db = db(vout_mag)
let dc_gain_db = gain_db[0]
print dc_gain_db

if dc_gain_db > 0
    meas ac ugbw WHEN gain_db=0 CROSS=1
end

quit
.endc

.end
