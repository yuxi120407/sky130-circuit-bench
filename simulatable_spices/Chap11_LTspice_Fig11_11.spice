* CIRCUIT: Chap11_LTspice/Fig11_11
* YAML: /home/idies/workspace/Storage/xyu1/persistent/ALIGN-public/simple_circuit_5/OpenManus/autosizer_plus/circuits_yaml_generated/Chap11_LTspice__Fig11_11.yaml
* Variables: ['W_M1', 'W_M2', 'C1']
* Trial values (midpoint): [1.47, 1.47, 5e-14]
* Metrics: ['avg_power', 'vout_swing', 'rise_time', 'fall_time', 'fom']
* Class: mosfet_digital_or_small

* Circuit: Chap11_LTspice/Fig11_11
.lib ${SKY130_PDK} tt

xm1 Vout Vin 0 0 sky130_fd_pr__nfet_01v8 w=1.47 l=0.15
Vin Vin 0 PULSE 0 1 500p 1p 1p 1000p
VDD VDD 0 1
xm2 Vout Vin VDD VDD sky130_fd_pr__pfet_01v8 w=1.47 l=0.15
C1 Vout 0 5e-14

.control
tran 1p 100n

let power = v(VDD) * abs(i(VDD))
let avg_power = mean(power)
print avg_power

meas tran vout_max MAX v(vout)
meas tran vout_min MIN v(vout)
let vout_swing = vout_max - vout_min
print vout_swing

meas tran rise_time TRIG v(vout) VAL='0.1*vout_max' RISE=1 TARG v(vout) VAL='0.9*vout_max' RISE=1
meas tran fall_time TRIG v(vout) VAL='0.9*vout_max' FALL=1 TARG v(vout) VAL='0.1*vout_max' FALL=1
print rise_time fall_time

quit
.endc

.end
